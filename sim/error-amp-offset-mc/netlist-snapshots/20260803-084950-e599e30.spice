** sch_path: /home/ubuntu/GitHub/sky130-bandgap/.loom/worktrees/issue-9/sim/error-amp-offset-mc/testbench/tb_amp_offset_mc.sch
**.subckt tb_amp_offset_mc
V1 VDD 0 'vsup'
XBG VREF GDRV VDD 0 bandgap_core
IE8S 0 E8S 5.3u
XXQ8S 0 0 E8S sky130_fd_pr__pnp_05v5_W0p68L0p68 m=8 mult=8
IE8L 0 E8L 5.3u
XXQ8L 0 0 E8L sky130_fd_pr__pnp_05v5_W3p40L3p40 m=8 mult=8
IE1S 0 E1S 1u
XXQ1S 0 0 E1S sky130_fd_pr__pnp_05v5_W0p68L0p68 m=1 mult=1
IE1L 0 E1L 1u
XXQ1L 0 0 E1L sky130_fd_pr__pnp_05v5_W3p40L3p40 m=1 mult=1
IRA 0 NRA 1u
XXRRA 0 NRA 0 sky130_fd_pr__res_high_po W=1 L=270 mult=1 m=1
IRB 0 NRB 1u
XXRRB 0 NRB 0 sky130_fd_pr__res_high_po W=1 L=35 mult=1 m=1
**** begin user architecture code

* DC-solver seed, not a forced solution: bandgap_core has a stable
* zero-current state by construction (issue #10's startup circuit is what
* breaks it in silicon). A .nodeset only biases the initial guess and is
* removed before the final Newton iterations, so each Monte Carlo sample is a
* genuine solution of that sample's circuit -- and the same seed is applied to
* every sample, so it cannot bias the spread.
*
* v(gdrv)=2.0 rather than the 2.2 sim/bandgap-smoke and sim/error-amp-loop
* use, and the difference is load-bearing HERE and nowhere else. The mirror
* gate settles near 1.97 V, so a 2.2 V guess sits on the wrong side of it;
* the deterministic runs converge anyway, but under Monte Carlo 12 of 40
* draws at -40 degC converged instead to the core's other stable solution
* (VOUT ~ 0.52 V), which would have shown up as a 350 mV sigma. With 2.0 V
* the same 40 draws all land on the operating solution. Verified not to be
* the tail wagging the dog: at 27 degC, where neither guess produces a
* degenerate sample, the two nodesets give sigma(VOUT) = 5.57 vs 5.67 mV and
* sigma(VOS) = 0.485 vs 0.495 mV over the same 40 draws -- i.e. the guess
* moves which *solution branch* the solver finds, not the spread it reports.
* The runner also classifies every sample and refuses to fold a
* non-operating one into the statistics, so this is belt and braces.
.nodeset v(vref)=1.2 v(gdrv)=2.0

**** end user architecture code
**.ends

* expanding   symbol:  design/bandgap_core.sym # of pins=4
** sym_path: /home/ubuntu/GitHub/sky130-bandgap/.loom/worktrees/issue-9/design/bandgap_core.sym
** sch_path: /home/ubuntu/GitHub/sky130-bandgap/.loom/worktrees/issue-9/design/bandgap_core.sch
.subckt bandgap_core VOUT GDRV VDD VSS
*.opin VOUT
*.iopin GDRV
*.iopin VDD
*.iopin VSS
**** begin user architecture code

* ---- Kuijk core parameters (issue #8) ----
* PNP emitter-area ratio N is built ONLY from paralleled unit devices:
*   N = (n_pnp_ptat * 11.56 um2) / (n_pnp_ctat * 0.4624 um2)
* Keep both counts equal to hold the pair's measured dVBE while lowering the
* per-unit current and sigma(dVBE); raise n_pnp_ptat alone for more PTAT.
.param n_pnp_ctat=8
.param n_pnp_ptat=8
* res_high_po unit segment: W = r_w um, L = r_lseg um (R ~ 380 + 325*L ohm)
.param r_w=1
.param r_lseg=5
* segment counts. K = R2/R1 is set by the integer ratio n_r2/n_r1.
.param n_r1=7
.param n_r2=54
* PMOS mirror multiplicities (unit device W=8u L=2u)
.param m_out=2
.param m_ampbias=2

**** end user architecture code
XMPOUT VOUT GDRV VDD VDD sky130_fd_pr__pfet_g5v0d10v5 L=2 W=8 nf=1 ad=2.32 as=2.32 pd=16.58 ps=16.58 nrd=0.03625 nrs=0.03625 sa=0 sb=0
+ sd=0 mult='m_out' m='m_out'
XMPAMP TAIL GDRV VDD VDD sky130_fd_pr__pfet_g5v0d10v5 L=2 W=8 nf=1 ad=2.32 as=2.32 pd=16.58 ps=16.58 nrd=0.03625 nrs=0.03625 sa=0 sb=0
+ sd=0 mult='m_ampbias' m='m_ampbias'
XAMP VB VA GDRV TAIL VDD VSS error_amp
XR2A VA VOUT VSS sky130_fd_pr__res_high_po W='r_w' L='r_lseg*n_r2' mult=1 m=1
XR2B VB VOUT VSS sky130_fd_pr__res_high_po W='r_w' L='r_lseg*n_r2' mult=1 m=1
XQ1 VSS VSS VA sky130_fd_pr__pnp_05v5_W0p68L0p68 m='n_pnp_ctat' mult='n_pnp_ctat'
XR1 VBQ VB VSS sky130_fd_pr__res_high_po W='r_w' L='r_lseg*n_r1' mult=1 m=1
XQ2 VSS VSS VBQ sky130_fd_pr__pnp_05v5_W3p40L3p40 m='n_pnp_ptat' mult='n_pnp_ptat'
.ends

* expanding   symbol:  design/error_amp.sym # of pins=6
** sym_path: /home/ubuntu/GitHub/sky130-bandgap/.loom/worktrees/issue-9/design/error_amp.sym
** sch_path: /home/ubuntu/GitHub/sky130-bandgap/.loom/worktrees/issue-9/design/error_amp.sch
.subckt error_amp VINP VINN AOUT ITAIL VDD VSS
*.ipin VINP
*.ipin VINN
*.opin AOUT
*.iopin ITAIL
*.iopin VDD
*.iopin VSS
**** begin user architecture code

* ---- error-amp device multiplicities (issue #9 sizing) ----
* Unit geometry is fixed on the instances below; mult is the matching axis
* (sigma(Vth) scales as 1/sqrt(W*L*mult) in the PDK's own model).
* amp_m_in    : input-pair PMOS units   (W=20u L=10u each -> 3200 um^2 total)
* amp_m_nmirr : NMOS load/mirror units  (W=8u  L=20u each ->  640 um^2 total)
* amp_m_pmirr : PMOS mirror units       (W=6u  L=20u each ->  960 um^2 total)
* amp_m_cc    : MOS-capacitor units     (W=30u L=20u each -> 9600 um^2 total)
.param amp_m_in=16
.param amp_m_nmirr=4
.param amp_m_pmirr=8
.param amp_m_cc=16

**** end user architecture code
XMP1 D1 VINP ITAIL VDD sky130_fd_pr__pfet_g5v0d10v5 L=10 W=20 nf=1 ad=5.8 as=5.8 pd=40.58 ps=40.58 nrd=0.0145 nrs=0.0145 sa=0 sb=0 sd=0 mult='amp_m_in' m='amp_m_in'
XMP2 D2 VINN ITAIL VDD sky130_fd_pr__pfet_g5v0d10v5 L=10 W=20 nf=1 ad=5.8 as=5.8 pd=40.58 ps=40.58 nrd=0.0145 nrs=0.0145 sa=0 sb=0 sd=0 mult='amp_m_in' m='amp_m_in'
XMN1 D1 D1 VSS VSS sky130_fd_pr__nfet_g5v0d10v5 L=20 W=8 nf=1 ad=2.32 as=2.32 pd=16.58 ps=16.58 nrd=0.03625 nrs=0.03625 sa=0 sb=0 sd=0 mult='amp_m_nmirr' m='amp_m_nmirr'
XMN2 D2 D2 VSS VSS sky130_fd_pr__nfet_g5v0d10v5 L=20 W=8 nf=1 ad=2.32 as=2.32 pd=16.58 ps=16.58 nrd=0.03625 nrs=0.03625 sa=0 sb=0 sd=0 mult='amp_m_nmirr' m='amp_m_nmirr'
XMN3 AOUT D1 VSS VSS sky130_fd_pr__nfet_g5v0d10v5 L=20 W=8 nf=1 ad=2.32 as=2.32 pd=16.58 ps=16.58 nrd=0.03625 nrs=0.03625 sa=0 sb=0 sd=0 mult='amp_m_nmirr' m='amp_m_nmirr'
XMN4 PN D2 VSS VSS sky130_fd_pr__nfet_g5v0d10v5 L=20 W=8 nf=1 ad=2.32 as=2.32 pd=16.58 ps=16.58 nrd=0.03625 nrs=0.03625 sa=0 sb=0 sd=0 mult='amp_m_nmirr' m='amp_m_nmirr'
XMP4 AOUT PN VDD VDD sky130_fd_pr__pfet_g5v0d10v5 L=20 W=6 nf=1 ad=1.74 as=1.74 pd=12.58 ps=12.58 nrd=0.0483333333333333 nrs=0.0483333333333333 sa=0 sb=0 sd=0 mult='amp_m_pmirr' m='amp_m_pmirr'
XMP3 PN PN VDD VDD sky130_fd_pr__pfet_g5v0d10v5 L=20 W=6 nf=1 ad=1.74 as=1.74 pd=12.58 ps=12.58 nrd=0.0483333333333333 nrs=0.0483333333333333 sa=0 sb=0 sd=0 mult='amp_m_pmirr' m='amp_m_pmirr'
XMCC VDD AOUT VDD VDD sky130_fd_pr__pfet_g5v0d10v5 L=20 W=30 nf=1 ad=8.7 as=8.7 pd=60.58 ps=60.58 nrd=0.00966666666666667 nrs=0.00966666666666667 sa=0 sb=0 sd=0 mult='amp_m_cc' m='amp_m_cc'
.ends

.end
