* extracted by klt extract --deck sky130
* parasitic model (--parasitics):
* - capacitance: net-to-ground for every net's own (non-coupled) area/perimeter, plus net-to-net for the vertical-overlap coupling `coupling` describes below -- a coupled net pair gets a direct capacitor between their two hub nodes, not just capacitors to the deck's ground/substrate net
* - coupling: vertical overlap (crossover) unconditionally -- where one net's conductor on an adjacent metal level sits directly over another *distinct* net's conductor, that overlap area is charged between the two nets instead of to ground (issue #760) -- plus lateral (same-layer, sidewall) coupling, but only for a net pair naming one of the caller's declared `--critical-net` nets (issue #976): facing-edge length within that layer's own minimum-spacing lookback is charged between the two nets, *additively* (not deducted from either net's substrate fringe term, unlike the vertical case -- a known simplification). Any same-layer pair with neither side named `--critical-net`, and fringe shielding in general, are still not modelled
* - resistance: single lumped series resistance per net, distributed as a star across that net's device terminals (issue #592) -- not a per-segment, distributed RC ladder, *unless* `--distributed-rc` names this net via `--critical-net` (issue #977, Epic #709 Phase 2b): then the net's terminals are ordered along their approximate physical spread and its total R/C is broken into a chain of per-segment resistors (segment length proportional to inter-terminal distance) with a ground capacitor at each terminal node (proportional to its adjacent segment length/2), instead of one star hub -- still an approximation (terminal position is a device-placement proxy, not true per-segment routing geometry), but a strictly finer-grained one than the single-hub star
* - frequency: quasi-static -- one frequency-independent R and C per net; no skin effect, no distributed transmission-line behavior
* - substrate tie: 1e+12 ohm to ground -- the substrate is capacitively floating in transient analysis (DC reference only); see --substrate-tie-ohms
.GLOBAL vsubs

* cell bandgap_core_routed
* pin D1
* pin D2
* pin GDRV
* pin NE
* pin NG
* pin PN
* pin TAIL
* pin VA
* pin VB
* pin VBQ
* pin VDD
* pin VOUT
* pin VSS
.SUBCKT bandgap_core_routed D1 D2 GDRV NE NG PN TAIL VA VB VBQ VDD VOUT VSS
* device instance $1 r0 *1 180.13,52.67 nfet
M$1 VSS__t190 D1__t5 D1__t10 VSS__t169 nfet L=20U W=8U AS=3.36P AD=3.36P
+ PS=16.84U PD=16.84U
* device instance $2 r0 *1 201.37,52.67 nfet
M$2 VSS__t199 D2__t7 D2__t10 VSS__t170 nfet L=20U W=8U AS=3.36P AD=3.36P
+ PS=16.84U PD=16.84U
* device instance $3 r0 *1 222.61,52.67 nfet
M$3 VSS__t200 D1__t3 D1__t8 VSS__t171 nfet L=20U W=8U AS=3.36P AD=3.36P
+ PS=16.84U PD=16.84U
* device instance $4 r0 *1 243.85,52.67 nfet
M$4 VSS__t201 D2__t8 D2__t11 VSS__t172 nfet L=20U W=8U AS=3.36P AD=3.36P
+ PS=16.84U PD=16.84U
* device instance $5 r0 *1 180.13,61.49 nfet
M$5 VSS__t202 D2__t2 D2__t1 VSS__t173 nfet L=20U W=8U AS=3.36P AD=3.36P
+ PS=16.84U PD=16.84U
* device instance $6 r0 *1 201.37,61.49 nfet
M$6 VSS__t203 D1__t4 D1__t9 VSS__t174 nfet L=20U W=8U AS=3.36P AD=3.36P
+ PS=16.84U PD=16.84U
* device instance $7 r0 *1 222.61,61.49 nfet
M$7 VSS__t204 D2__t9 D2__t12 VSS__t175 nfet L=20U W=8U AS=3.36P AD=3.36P
+ PS=16.84U PD=16.84U
* device instance $8 r0 *1 243.85,61.49 nfet
M$8 VSS__t205 D1__t6 D1__t11 VSS__t176 nfet L=20U W=8U AS=3.36P AD=3.36P
+ PS=16.84U PD=16.84U
* device instance $9 r0 *1 208.02,105.9 nfet
M$9 VSS__t193 D2__t3 PN__t1 VSS__t177 nfet L=20U W=8U AS=3.36P AD=3.36P
+ PS=16.84U PD=16.84U
* device instance $10 r0 *1 229.26,105.9 nfet
M$10 VSS__t206 D1__t7 GDRV__t24 VSS__t178 nfet L=20U W=8U AS=3.36P AD=3.36P
+ PS=16.84U PD=16.84U
* device instance $11 r0 *1 250.5,105.9 nfet
M$11 VSS__t194 D2__t4 PN__t2 VSS__t179 nfet L=20U W=8U AS=3.36P AD=3.36P
+ PS=16.84U PD=16.84U
* device instance $12 r0 *1 271.74,105.9 nfet
M$12 VSS__t192 D1__t0 GDRV__t21 VSS__t180 nfet L=20U W=8U AS=3.36P AD=3.36P
+ PS=16.84U PD=16.84U
* device instance $13 r0 *1 208.02,114.72 nfet
M$13 VSS__t195 D1__t1 GDRV__t22 VSS__t181 nfet L=20U W=8U AS=3.36P AD=3.36P
+ PS=16.84U PD=16.84U
* device instance $14 r0 *1 229.26,114.72 nfet
M$14 VSS__t196 D2__t5 PN__t3 VSS__t182 nfet L=20U W=8U AS=3.36P AD=3.36P
+ PS=16.84U PD=16.84U
* device instance $15 r0 *1 250.5,114.72 nfet
M$15 VSS__t197 D1__t2 GDRV__t23 VSS__t183 nfet L=20U W=8U AS=3.36P AD=3.36P
+ PS=16.84U PD=16.84U
* device instance $16 r0 *1 271.74,114.72 nfet
M$16 VSS__t198 D2__t6 PN__t4 VSS__t184 nfet L=20U W=8U AS=3.36P AD=3.36P
+ PS=16.84U PD=16.84U
* device instance $17 r0 *1 0.92,144.06 nfet
M$17 VDD__t5 VOUT__t2 GDRV__t2 VSS__t185 nfet L=1U W=4U AS=1.68P AD=1.68P
+ PS=8.84U PD=8.84U
* device instance $18 r0 *1 103.77,173.34 nfet
M$18 GDRV__t5 NG__t3 VSS__t191 VSS__t186 nfet L=0.5U W=10U AS=4.2P AD=4.2P
+ PS=20.84U PD=20.84U
* device instance $19 r0 *1 18.51,173.34 nfet
M$19 NG__t0 VOUT__t3 NE__t0 VSS__t187 nfet L=0.5U W=48U AS=20.16P AD=20.16P
+ PS=96.84U PD=96.84U
* device instance $20 r0 *1 67.62,46.67 pfet
M$20 D2__t0 VA__t1 TAIL__t2 VDD__t57 pfet L=10U W=20U AS=8.4P AD=8.4P PS=40.84U
+ PD=40.84U
* device instance $21 r0 *1 78.86,46.67 pfet
M$21 D1__t14 VB__t2 TAIL__t8 VDD__t63 pfet L=10U W=20U AS=8.4P AD=8.4P
+ PS=40.84U PD=40.84U
* device instance $22 r0 *1 90.1,46.67 pfet
M$22 D2__t16 VA__t5 TAIL__t7 VDD__t62 pfet L=10U W=20U AS=8.4P AD=8.4P
+ PS=40.84U PD=40.84U
* device instance $23 r0 *1 101.34,46.67 pfet
M$23 D1__t13 VB__t1 TAIL__t6 VDD__t61 pfet L=10U W=20U AS=8.4P AD=8.4P
+ PS=40.84U PD=40.84U
* device instance $24 r0 *1 112.58,46.67 pfet
M$24 D2__t15 VA__t4 TAIL__t5 VDD__t60 pfet L=10U W=20U AS=8.4P AD=8.4P
+ PS=40.84U PD=40.84U
* device instance $25 r0 *1 123.82,46.67 pfet
M$25 D1__t12 VB TAIL__t4 VDD__t59 pfet L=10U W=20U AS=8.4P AD=8.4P PS=40.84U
+ PD=40.84U
* device instance $26 r0 *1 135.06,46.67 pfet
M$26 D2__t14 VA__t3 TAIL__t3 VDD__t58 pfet L=10U W=20U AS=8.4P AD=8.4P
+ PS=40.84U PD=40.84U
* device instance $27 r0 *1 146.3,46.67 pfet
M$27 D1__t19 VB__t7 TAIL__t15 VDD__t70 pfet L=10U W=20U AS=8.4P AD=8.4P
+ PS=40.84U PD=40.84U
* device instance $28 r0 *1 39.4,61.49 pfet
M$28 TAIL__t16 GDRV__t25 VDD__t74 VDD__t71 pfet L=2U W=8U AS=3.36P AD=3.36P
+ PS=16.84U PD=16.84U
* device instance $29 r0 *1 39.4,52.67 pfet
M$29 VOUT__t1 GDRV__t1 VDD__t2 VDD__t3 pfet L=2U W=8U AS=3.36P AD=3.36P
+ PS=16.84U PD=16.84U
* device instance $30 r0 *1 42.64,61.49 pfet
M$30 VOUT__t4 GDRV__t26 VDD__t75 VDD__t72 pfet L=2U W=8U AS=3.36P AD=3.36P
+ PS=16.84U PD=16.84U
* device instance $31 r0 *1 42.64,52.67 pfet
M$31 TAIL__t17 GDRV__t27 VDD__t76 VDD__t73 pfet L=2U W=8U AS=3.36P AD=3.36P
+ PS=16.84U PD=16.84U
* device instance $32 r0 *1 67.62,67.49 pfet
M$32 D1__t15 VB__t3 TAIL__t0 VDD__t4 pfet L=10U W=20U AS=8.4P AD=8.4P PS=40.84U
+ PD=40.84U
* device instance $33 r0 *1 78.86,67.49 pfet
M$33 D2__t19 VA__t8 TAIL__t14 VDD__t69 pfet L=10U W=20U AS=8.4P AD=8.4P
+ PS=40.84U PD=40.84U
* device instance $34 r0 *1 90.1,67.49 pfet
M$34 D1__t16 VB__t4 TAIL__t9 VDD__t64 pfet L=10U W=20U AS=8.4P AD=8.4P
+ PS=40.84U PD=40.84U
* device instance $35 r0 *1 101.34,67.49 pfet
M$35 D2__t17 VA__t6 TAIL__t10 VDD__t65 pfet L=10U W=20U AS=8.4P AD=8.4P
+ PS=40.84U PD=40.84U
* device instance $36 r0 *1 112.58,67.49 pfet
M$36 D1__t17 VB__t5 TAIL__t11 VDD__t66 pfet L=10U W=20U AS=8.4P AD=8.4P
+ PS=40.84U PD=40.84U
* device instance $37 r0 *1 123.82,67.49 pfet
M$37 D2__t18 VA__t7 TAIL__t12 VDD__t67 pfet L=10U W=20U AS=8.4P AD=8.4P
+ PS=40.84U PD=40.84U
* device instance $38 r0 *1 135.06,67.49 pfet
M$38 D1__t18 VB__t6 TAIL__t13 VDD__t68 pfet L=10U W=20U AS=8.4P AD=8.4P
+ PS=40.84U PD=40.84U
* device instance $39 r0 *1 146.3,67.49 pfet
M$39 D2__t13 VA__t2 TAIL__t1 VDD__t56 pfet L=10U W=20U AS=8.4P AD=8.4P
+ PS=40.84U PD=40.84U
* device instance $40 r0 *1 20.51,106.9 pfet
M$40 PN__t23 PN__t0 VDD__t0 VDD__t1 pfet L=20U W=6U AS=2.52P AD=2.52P PS=12.84U
+ PD=12.84U
* device instance $41 r0 *1 20.51,113.72 pfet
M$41 GDRV__t0 PN__t13 VDD__t100 VDD__t85 pfet L=20U W=6U AS=2.52P AD=2.52P
+ PS=12.84U PD=12.84U
* device instance $42 r0 *1 41.75,113.72 pfet
M$42 PN__t24 PN__t14 VDD__t101 VDD__t86 pfet L=20U W=6U AS=2.52P AD=2.52P
+ PS=12.84U PD=12.84U
* device instance $43 r0 *1 41.75,106.9 pfet
M$43 GDRV__t32 PN__t12 VDD__t99 VDD__t84 pfet L=20U W=6U AS=2.52P AD=2.52P
+ PS=12.84U PD=12.84U
* device instance $44 r0 *1 62.99,113.72 pfet
M$44 GDRV__t31 PN__t11 VDD__t98 VDD__t83 pfet L=20U W=6U AS=2.52P AD=2.52P
+ PS=12.84U PD=12.84U
* device instance $45 r0 *1 62.99,106.9 pfet
M$45 PN__t22 PN__t10 VDD__t97 VDD__t82 pfet L=20U W=6U AS=2.52P AD=2.52P
+ PS=12.84U PD=12.84U
* device instance $46 r0 *1 84.23,106.9 pfet
M$46 GDRV__t30 PN__t9 VDD__t96 VDD__t81 pfet L=20U W=6U AS=2.52P AD=2.52P
+ PS=12.84U PD=12.84U
* device instance $47 r0 *1 84.23,113.72 pfet
M$47 PN__t20 PN__t5 VDD__t92 VDD__t77 pfet L=20U W=6U AS=2.52P AD=2.52P
+ PS=12.84U PD=12.84U
* device instance $48 r0 *1 105.47,106.9 pfet
M$48 PN__t27 PN__t19 VDD__t106 VDD__t91 pfet L=20U W=6U AS=2.52P AD=2.52P
+ PS=12.84U PD=12.84U
* device instance $49 r0 *1 105.47,113.72 pfet
M$49 GDRV__t29 PN__t8 VDD__t95 VDD__t80 pfet L=20U W=6U AS=2.52P AD=2.52P
+ PS=12.84U PD=12.84U
* device instance $50 r0 *1 126.71,106.9 pfet
M$50 GDRV__t28 PN__t6 VDD__t93 VDD__t78 pfet L=20U W=6U AS=2.52P AD=2.52P
+ PS=12.84U PD=12.84U
* device instance $51 r0 *1 126.71,113.72 pfet
M$51 PN__t21 PN__t7 VDD__t94 VDD__t79 pfet L=20U W=6U AS=2.52P AD=2.52P
+ PS=12.84U PD=12.84U
* device instance $52 r0 *1 147.95,106.9 pfet
M$52 PN__t26 PN__t18 VDD__t105 VDD__t90 pfet L=20U W=6U AS=2.52P AD=2.52P
+ PS=12.84U PD=12.84U
* device instance $53 r0 *1 147.95,113.72 pfet
M$53 GDRV__t34 PN__t17 VDD__t104 VDD__t89 pfet L=20U W=6U AS=2.52P AD=2.52P
+ PS=12.84U PD=12.84U
* device instance $54 r0 *1 169.19,113.72 pfet
M$54 PN__t25 PN__t16 VDD__t103 VDD__t88 pfet L=20U W=6U AS=2.52P AD=2.52P
+ PS=12.84U PD=12.84U
* device instance $55 r0 *1 169.19,106.9 pfet
M$55 GDRV__t33 PN__t15 VDD__t102 VDD__t87 pfet L=20U W=6U AS=2.52P AD=2.52P
+ PS=12.84U PD=12.84U
* device instance $56 r0 *1 131.93,158.13 pfet
M$56 VDD__t7 GDRV__t3 VDD__t6 VDD__t8 pfet L=20U W=30U AS=12.6P AD=12.6P
+ PS=60.84U PD=60.84U
* device instance $57 r0 *1 153.17,158.13 pfet
M$57 VDD__t35 GDRV__t15 VDD__t50 VDD__t20 pfet L=20U W=30U AS=12.6P AD=12.6P
+ PS=60.84U PD=60.84U
* device instance $58 r0 *1 174.41,158.13 pfet
M$58 VDD__t27 GDRV__t7 VDD__t42 VDD__t12 pfet L=20U W=30U AS=12.6P AD=12.6P
+ PS=60.84U PD=60.84U
* device instance $59 r0 *1 195.65,158.13 pfet
M$59 VDD__t28 GDRV__t8 VDD__t43 VDD__t13 pfet L=20U W=30U AS=12.6P AD=12.6P
+ PS=60.84U PD=60.84U
* device instance $60 r0 *1 216.89,158.13 pfet
M$60 VDD__t30 GDRV__t10 VDD__t45 VDD__t15 pfet L=20U W=30U AS=12.6P AD=12.6P
+ PS=60.84U PD=60.84U
* device instance $61 r0 *1 238.13,158.13 pfet
M$61 VDD__t38 GDRV__t18 VDD__t53 VDD__t23 pfet L=20U W=30U AS=12.6P AD=12.6P
+ PS=60.84U PD=60.84U
* device instance $62 r0 *1 259.37,158.13 pfet
M$62 VDD__t26 GDRV__t6 VDD__t41 VDD__t11 pfet L=20U W=30U AS=12.6P AD=12.6P
+ PS=60.84U PD=60.84U
* device instance $63 r0 *1 280.61,158.13 pfet
M$63 VDD__t39 GDRV__t19 VDD__t54 VDD__t24 pfet L=20U W=30U AS=12.6P AD=12.6P
+ PS=60.84U PD=60.84U
* device instance $64 r0 *1 75.61,174.45 pfet
M$64 NG__t1 NG__t2 \$182__t2 VDD__t9 pfet L=20U W=1U AS=0.42P AD=0.42P PS=2.84U
+ PD=2.84U
* device instance $65 r0 *1 75.61,172.63 pfet
M$65 \$182__t1 \$182__t0 GDRV__t4 VDD__t10 pfet L=20U W=1U AS=0.42P AD=0.42P
+ PS=2.84U PD=2.84U
* device instance $66 r0 *1 131.93,188.95 pfet
M$66 VDD__t37 GDRV__t17 VDD__t52 VDD__t22 pfet L=20U W=30U AS=12.6P AD=12.6P
+ PS=60.84U PD=60.84U
* device instance $67 r0 *1 153.17,188.95 pfet
M$67 VDD__t29 GDRV__t9 VDD__t44 VDD__t14 pfet L=20U W=30U AS=12.6P AD=12.6P
+ PS=60.84U PD=60.84U
* device instance $68 r0 *1 174.41,188.95 pfet
M$68 VDD__t36 GDRV__t16 VDD__t51 VDD__t21 pfet L=20U W=30U AS=12.6P AD=12.6P
+ PS=60.84U PD=60.84U
* device instance $69 r0 *1 195.65,188.95 pfet
M$69 VDD__t34 GDRV__t14 VDD__t49 VDD__t19 pfet L=20U W=30U AS=12.6P AD=12.6P
+ PS=60.84U PD=60.84U
* device instance $70 r0 *1 216.89,188.95 pfet
M$70 VDD__t33 GDRV__t13 VDD__t48 VDD__t18 pfet L=20U W=30U AS=12.6P AD=12.6P
+ PS=60.84U PD=60.84U
* device instance $71 r0 *1 238.13,188.95 pfet
M$71 VDD__t32 GDRV__t12 VDD__t47 VDD__t17 pfet L=20U W=30U AS=12.6P AD=12.6P
+ PS=60.84U PD=60.84U
* device instance $72 r0 *1 259.37,188.95 pfet
M$72 VDD__t31 GDRV__t11 VDD__t46 VDD__t16 pfet L=20U W=30U AS=12.6P AD=12.6P
+ PS=60.84U PD=60.84U
* device instance $73 r0 *1 280.61,188.95 pfet
M$73 VDD__t40 GDRV__t20 VDD__t55 VDD__t25 pfet L=20U W=30U AS=12.6P AD=12.6P
+ PS=60.84U PD=60.84U
* device instance $74 r0 *1 12.96,1.31 pnp
Q$74 VSS__t0 VSS__t188 VA__t0 pnp AE=0.4624P PE=2.72U AB=0.7744P PB=3.52U
+ AC=0.7744P PC=3.52U NE=1
* device instance $75 r0 *1 14.86,1.31 pnp
Q$75 VSS__t1 VSS__t227 VA__t15 pnp AE=0.4624P PE=2.72U AB=0.7744P PB=3.52U
+ AC=0.7744P PC=3.52U NE=1
* device instance $76 r0 *1 16.76,1.31 pnp
Q$76 VSS__t2 VSS__t226 VA__t14 pnp AE=0.4624P PE=2.72U AB=0.7744P PB=3.52U
+ AC=0.7744P PC=3.52U NE=1
* device instance $77 r0 *1 18.66,1.31 pnp
Q$77 VSS__t3 VSS__t225 VA__t13 pnp AE=0.4624P PE=2.72U AB=0.7744P PB=3.52U
+ AC=0.7744P PC=3.52U NE=1
* device instance $78 r0 *1 12.96,2.39 pnp
Q$78 VSS__t4 VSS__t224 VA__t12 pnp AE=0.4624P PE=2.72U AB=0.7744P PB=3.52U
+ AC=0.7744P PC=3.52U NE=1
* device instance $79 r0 *1 14.86,2.39 pnp
Q$79 VSS__t5 VSS__t223 VA__t11 pnp AE=0.4624P PE=2.72U AB=0.7744P PB=3.52U
+ AC=0.7744P PC=3.52U NE=1
* device instance $80 r0 *1 16.76,2.39 pnp
Q$80 VSS__t6 VSS__t214 VA__t10 pnp AE=0.4624P PE=2.72U AB=0.7744P PB=3.52U
+ AC=0.7744P PC=3.52U NE=1
* device instance $81 r0 *1 18.66,2.39 pnp
Q$81 VSS__t7 VSS__t228 VA__t16 pnp AE=0.4624P PE=2.72U AB=0.7744P PB=3.52U
+ AC=0.7744P PC=3.52U NE=1
* device instance $82 r0 *1 260.38,2.67 pnp
Q$82 VSS__t16 VSS__t189 VBQ__t0 pnp AE=11.56P PE=13.6U AB=12.96P PB=14.4U
+ AC=12.96P PC=14.4U NE=1
* device instance $83 r0 *1 265,2.67 pnp
Q$83 VSS__t17 VSS__t212 VBQ pnp AE=11.56P PE=13.6U AB=12.96P PB=14.4U AC=12.96P
+ PC=14.4U NE=1
* device instance $84 r0 *1 269.62,2.67 pnp
Q$84 VSS__t18 VSS__t211 VBQ__t5 pnp AE=11.56P PE=13.6U AB=12.96P PB=14.4U
+ AC=12.96P PC=14.4U NE=1
* device instance $85 r0 *1 274.24,2.67 pnp
Q$85 VSS__t19 VSS__t210 VBQ__t4 pnp AE=11.56P PE=13.6U AB=12.96P PB=14.4U
+ AC=12.96P PC=14.4U NE=1
* device instance $86 r0 *1 260.38,6.47 pnp
Q$86 VSS__t20 VSS__t209 VBQ__t3 pnp AE=11.56P PE=13.6U AB=12.96P PB=14.4U
+ AC=12.96P PC=14.4U NE=1
* device instance $87 r0 *1 265,6.47 pnp
Q$87 VSS__t21 VSS__t208 VBQ__t2 pnp AE=11.56P PE=13.6U AB=12.96P PB=14.4U
+ AC=12.96P PC=14.4U NE=1
* device instance $88 r0 *1 269.62,6.47 pnp
Q$88 VSS__t22 VSS__t213 VBQ__t7 pnp AE=11.56P PE=13.6U AB=12.96P PB=14.4U
+ AC=12.96P PC=14.4U NE=1
* device instance $89 r0 *1 274.24,6.47 pnp
Q$89 VSS__t23 VSS__t207 VBQ__t1 pnp AE=11.56P PE=13.6U AB=12.96P PB=14.4U
+ AC=12.96P PC=14.4U NE=1
* device instance $90 r0 *1 38.39,143.37 pnp
Q$90 VSS__t8 VSS__t215 NE__t1 pnp AE=0.4624P PE=2.72U AB=0.7744P PB=3.52U
+ AC=0.7744P PC=3.52U NE=1
* device instance $91 r0 *1 40.29,143.37 pnp
Q$91 VSS__t9 VSS__t216 NE__t2 pnp AE=0.4624P PE=2.72U AB=0.7744P PB=3.52U
+ AC=0.7744P PC=3.52U NE=1
* device instance $92 r0 *1 42.19,143.37 pnp
Q$92 VSS__t10 VSS__t217 NE__t3 pnp AE=0.4624P PE=2.72U AB=0.7744P PB=3.52U
+ AC=0.7744P PC=3.52U NE=1
* device instance $93 r0 *1 44.09,143.37 pnp
Q$93 VSS__t11 VSS__t218 NE__t4 pnp AE=0.4624P PE=2.72U AB=0.7744P PB=3.52U
+ AC=0.7744P PC=3.52U NE=1
* device instance $94 r0 *1 38.39,144.45 pnp
Q$94 VSS__t12 VSS__t219 NE__t5 pnp AE=0.4624P PE=2.72U AB=0.7744P PB=3.52U
+ AC=0.7744P PC=3.52U NE=1
* device instance $95 r0 *1 40.29,144.45 pnp
Q$95 VSS__t13 VSS__t220 NE__t6 pnp AE=0.4624P PE=2.72U AB=0.7744P PB=3.52U
+ AC=0.7744P PC=3.52U NE=1
* device instance $96 r0 *1 42.19,144.45 pnp
Q$96 VSS__t14 VSS__t221 NE__t7 pnp AE=0.4624P PE=2.72U AB=0.7744P PB=3.52U
+ AC=0.7744P PC=3.52U NE=1
* device instance $97 r0 *1 44.09,144.45 pnp
Q$97 VSS__t15 VSS__t222 NE__t8 pnp AE=0.4624P PE=2.72U AB=0.7744P PB=3.52U
+ AC=0.7744P PC=3.52U NE=1
* device instance $98 r0 *1 54.29,0.5 res_high_po
X$98 VOUT__t0 \$7__t0 VSS__t24 res_high_po r=2003.841367 L=5U W=1U
* device instance $99 r0 *1 60.63,0.5 res_high_po
X$99 VOUT__t5 \$8__t0 VSS__t25 res_high_po r=2003.841367 L=5U W=1U
* device instance $100 r0 *1 66.97,0.5 res_high_po
X$100 \$7__t1 \$9__t0 VSS__t26 res_high_po r=2003.841367 L=5U W=1U
* device instance $101 r0 *1 73.31,0.5 res_high_po
X$101 \$8__t1 \$10__t0 VSS__t27 res_high_po r=2003.841367 L=5U W=1U
* device instance $102 r0 *1 79.65,0.5 res_high_po
X$102 \$9__t1 \$11__t0 VSS__t28 res_high_po r=2003.841367 L=5U W=1U
* device instance $103 r0 *1 85.99,0.5 res_high_po
X$103 \$10__t1 \$12__t0 VSS__t29 res_high_po r=2003.841367 L=5U W=1U
* device instance $104 r0 *1 92.33,0.5 res_high_po
X$104 \$11__t1 \$13__t0 VSS__t30 res_high_po r=2003.841367 L=5U W=1U
* device instance $105 r0 *1 98.67,0.5 res_high_po
X$105 \$12__t1 \$14__t0 VSS__t31 res_high_po r=2003.841367 L=5U W=1U
* device instance $106 r0 *1 105.01,0.5 res_high_po
X$106 \$13__t1 \$15__t1 VSS__t32 res_high_po r=2003.841367 L=5U W=1U
* device instance $107 r0 *1 111.35,0.5 res_high_po
X$107 \$14__t1 \$16__t1 VSS__t33 res_high_po r=2003.841367 L=5U W=1U
* device instance $108 r0 *1 54.29,3.3 res_high_po
X$108 \$21__t0 \$36__t0 VSS__t44 res_high_po r=2003.841367 L=5U W=1U
* device instance $109 r0 *1 54.29,1.9 res_high_po
X$109 \$22__t0 \$23__t0 VSS__t34 res_high_po r=2003.841367 L=5U W=1U
* device instance $110 r0 *1 60.63,1.9 res_high_po
X$110 \$21__t1 \$24__t0 VSS__t35 res_high_po r=2003.841367 L=5U W=1U
* device instance $111 r0 *1 60.63,3.3 res_high_po
X$111 \$22__t1 \$37__t0 VSS__t45 res_high_po r=2003.841367 L=5U W=1U
* device instance $112 r0 *1 66.97,1.9 res_high_po
X$112 \$23__t1 \$25__t0 VSS__t36 res_high_po r=2003.841367 L=5U W=1U
* device instance $113 r0 *1 66.97,3.3 res_high_po
X$113 \$36__t1 \$38__t0 VSS__t46 res_high_po r=2003.841367 L=5U W=1U
* device instance $114 r0 *1 73.31,1.9 res_high_po
X$114 \$24__t1 \$26__t0 VSS__t37 res_high_po r=2003.841367 L=5U W=1U
* device instance $115 r0 *1 73.31,3.3 res_high_po
X$115 \$37__t1 \$39__t0 VSS__t47 res_high_po r=2003.841367 L=5U W=1U
* device instance $116 r0 *1 79.65,1.9 res_high_po
X$116 \$25__t1 \$27__t0 VSS__t38 res_high_po r=2003.841367 L=5U W=1U
* device instance $117 r0 *1 79.65,3.3 res_high_po
X$117 \$38__t1 \$40__t0 VSS__t48 res_high_po r=2003.841367 L=5U W=1U
* device instance $118 r0 *1 85.99,3.3 res_high_po
X$118 \$39__t1 \$41__t0 VSS__t49 res_high_po r=2003.841367 L=5U W=1U
* device instance $119 r0 *1 85.99,1.9 res_high_po
X$119 \$26__t1 \$28__t0 VSS__t39 res_high_po r=2003.841367 L=5U W=1U
* device instance $120 r0 *1 92.33,1.9 res_high_po
X$120 \$27__t1 \$29__t0 VSS__t40 res_high_po r=2003.841367 L=5U W=1U
* device instance $121 r0 *1 92.33,3.3 res_high_po
X$121 \$40__t1 \$42__t0 VSS__t50 res_high_po r=2003.841367 L=5U W=1U
* device instance $122 r0 *1 98.67,3.3 res_high_po
X$122 \$41__t1 \$43__t0 VSS__t51 res_high_po r=2003.841367 L=5U W=1U
* device instance $123 r0 *1 98.67,1.9 res_high_po
X$123 \$28__t1 \$30__t0 VSS__t41 res_high_po r=2003.841367 L=5U W=1U
* device instance $124 r0 *1 105.01,3.3 res_high_po
X$124 \$42__t1 \$44__t0 VSS__t52 res_high_po r=2003.841367 L=5U W=1U
* device instance $125 r0 *1 105.01,1.9 res_high_po
X$125 \$29__t1 \$16__t0 VSS__t42 res_high_po r=2003.841367 L=5U W=1U
* device instance $126 r0 *1 111.35,1.9 res_high_po
X$126 \$30__t1 \$15__t0 VSS__t43 res_high_po r=2003.841367 L=5U W=1U
* device instance $127 r0 *1 111.35,3.3 res_high_po
X$127 \$43__t1 \$45__t1 VSS__t53 res_high_po r=2003.841367 L=5U W=1U
* device instance $128 r0 *1 54.29,4.7 res_high_po
X$128 \$47__t0 \$48__t0 VSS__t54 res_high_po r=2003.841367 L=5U W=1U
* device instance $129 r0 *1 60.63,4.7 res_high_po
X$129 \$46__t0 \$49__t0 VSS__t55 res_high_po r=2003.841367 L=5U W=1U
* device instance $130 r0 *1 66.97,4.7 res_high_po
X$130 \$48__t1 \$50__t0 VSS__t56 res_high_po r=2003.841367 L=5U W=1U
* device instance $131 r0 *1 73.31,4.7 res_high_po
X$131 \$49__t1 \$51__t0 VSS__t57 res_high_po r=2003.841367 L=5U W=1U
* device instance $132 r0 *1 79.65,4.7 res_high_po
X$132 \$50__t1 \$52__t0 VSS__t58 res_high_po r=2003.841367 L=5U W=1U
* device instance $133 r0 *1 85.99,4.7 res_high_po
X$133 \$51__t1 \$53__t0 VSS__t59 res_high_po r=2003.841367 L=5U W=1U
* device instance $134 r0 *1 92.33,4.7 res_high_po
X$134 \$52__t1 \$54__t0 VSS__t60 res_high_po r=2003.841367 L=5U W=1U
* device instance $135 r0 *1 98.67,4.7 res_high_po
X$135 \$53__t1 \$55__t0 VSS__t61 res_high_po r=2003.841367 L=5U W=1U
* device instance $136 r0 *1 105.01,4.7 res_high_po
X$136 \$54__t1 \$45__t0 VSS__t62 res_high_po r=2003.841367 L=5U W=1U
* device instance $137 r0 *1 111.35,4.7 res_high_po
X$137 \$55__t1 \$44__t1 VSS__t63 res_high_po r=2003.841367 L=5U W=1U
* device instance $138 r0 *1 54.29,6.1 res_high_po
X$138 \$46__t1 \$56__t0 VSS__t64 res_high_po r=2003.841367 L=5U W=1U
* device instance $139 r0 *1 60.63,6.1 res_high_po
X$139 \$47__t1 \$57__t0 VSS__t65 res_high_po r=2003.841367 L=5U W=1U
* device instance $140 r0 *1 66.97,6.1 res_high_po
X$140 \$56__t1 \$58__t0 VSS__t66 res_high_po r=2003.841367 L=5U W=1U
* device instance $141 r0 *1 73.31,6.1 res_high_po
X$141 \$57__t1 \$59__t0 VSS__t67 res_high_po r=2003.841367 L=5U W=1U
* device instance $142 r0 *1 79.65,6.1 res_high_po
X$142 \$58__t1 \$60__t0 VSS__t68 res_high_po r=2003.841367 L=5U W=1U
* device instance $143 r0 *1 85.99,6.1 res_high_po
X$143 \$59__t1 \$61__t0 VSS__t69 res_high_po r=2003.841367 L=5U W=1U
* device instance $144 r0 *1 92.33,6.1 res_high_po
X$144 \$60__t1 \$62__t0 VSS__t70 res_high_po r=2003.841367 L=5U W=1U
* device instance $145 r0 *1 98.67,6.1 res_high_po
X$145 \$61__t1 \$63__t0 VSS__t71 res_high_po r=2003.841367 L=5U W=1U
* device instance $146 r0 *1 105.01,6.1 res_high_po
X$146 \$62__t1 \$64__t1 VSS__t72 res_high_po r=2003.841367 L=5U W=1U
* device instance $147 r0 *1 111.35,6.1 res_high_po
X$147 \$63__t1 \$65__t1 VSS__t73 res_high_po r=2003.841367 L=5U W=1U
* device instance $148 r0 *1 54.29,7.5 res_high_po
X$148 \$67__t0 \$68__t0 VSS__t74 res_high_po r=2003.841367 L=5U W=1U
* device instance $149 r0 *1 60.63,7.5 res_high_po
X$149 \$66__t1 \$69__t0 VSS__t75 res_high_po r=2003.841367 L=5U W=1U
* device instance $150 r0 *1 66.97,7.5 res_high_po
X$150 \$68__t1 \$70__t0 VSS__t76 res_high_po r=2003.841367 L=5U W=1U
* device instance $151 r0 *1 73.31,7.5 res_high_po
X$151 \$69__t1 \$71__t0 VSS__t77 res_high_po r=2003.841367 L=5U W=1U
* device instance $152 r0 *1 79.65,7.5 res_high_po
X$152 \$70__t1 \$72__t0 VSS__t78 res_high_po r=2003.841367 L=5U W=1U
* device instance $153 r0 *1 85.99,7.5 res_high_po
X$153 \$71__t1 \$73__t0 VSS__t79 res_high_po r=2003.841367 L=5U W=1U
* device instance $154 r0 *1 92.33,7.5 res_high_po
X$154 \$72__t1 \$74__t0 VSS__t80 res_high_po r=2003.841367 L=5U W=1U
* device instance $155 r0 *1 98.67,7.5 res_high_po
X$155 \$73__t1 \$75__t0 VSS__t81 res_high_po r=2003.841367 L=5U W=1U
* device instance $156 r0 *1 105.01,7.5 res_high_po
X$156 \$74__t1 \$65__t0 VSS__t82 res_high_po r=2003.841367 L=5U W=1U
* device instance $157 r0 *1 111.35,7.5 res_high_po
X$157 \$75__t1 \$64__t0 VSS__t83 res_high_po r=2003.841367 L=5U W=1U
* device instance $158 r0 *1 54.29,8.9 res_high_po
X$158 \$66__t0 \$78__t0 VSS__t84 res_high_po r=2003.841367 L=5U W=1U
* device instance $159 r0 *1 60.63,8.9 res_high_po
X$159 \$67__t1 \$79__t0 VSS__t85 res_high_po r=2003.841367 L=5U W=1U
* device instance $160 r0 *1 66.97,8.9 res_high_po
X$160 \$78__t1 \$80__t0 VSS__t86 res_high_po r=2003.841367 L=5U W=1U
* device instance $161 r0 *1 73.31,8.9 res_high_po
X$161 \$79__t1 \$81__t0 VSS__t87 res_high_po r=2003.841367 L=5U W=1U
* device instance $162 r0 *1 79.65,8.9 res_high_po
X$162 \$80__t1 \$82__t0 VSS__t88 res_high_po r=2003.841367 L=5U W=1U
* device instance $163 r0 *1 85.99,8.9 res_high_po
X$163 \$81__t1 \$83__t0 VSS__t89 res_high_po r=2003.841367 L=5U W=1U
* device instance $164 r0 *1 92.33,8.9 res_high_po
X$164 \$82__t1 \$84__t0 VSS__t90 res_high_po r=2003.841367 L=5U W=1U
* device instance $165 r0 *1 98.67,8.9 res_high_po
X$165 \$83__t1 \$85__t0 VSS__t91 res_high_po r=2003.841367 L=5U W=1U
* device instance $166 r0 *1 105.01,8.9 res_high_po
X$166 \$84__t1 \$86__t1 VSS__t92 res_high_po r=2003.841367 L=5U W=1U
* device instance $167 r0 *1 111.35,8.9 res_high_po
X$167 \$85__t1 \$99__t1 VSS__t93 res_high_po r=2003.841367 L=5U W=1U
* device instance $168 r0 *1 134.62,8.9 res_high_po
X$168 \$2__t0 \$89__t0 VSS__t129 res_high_po r=542.118769 L=0.5U W=1U
* device instance $169 r0 *1 136.46,8.9 res_high_po
X$169 \$168__t0 \$90__t0 VSS__t130 res_high_po r=542.118769 L=0.5U W=1U
* device instance $170 r0 *1 138.3,8.9 res_high_po
X$170 \$89__t1 \$91__t0 VSS__t131 res_high_po r=542.118769 L=0.5U W=1U
* device instance $171 r0 *1 140.14,8.9 res_high_po
X$171 \$90__t1 \$92__t0 VSS__t132 res_high_po r=542.118769 L=0.5U W=1U
* device instance $172 r0 *1 141.98,8.9 res_high_po
X$172 \$91__t1 \$93__t0 VSS__t133 res_high_po r=542.118769 L=0.5U W=1U
* device instance $173 r0 *1 143.82,8.9 res_high_po
X$173 \$92__t1 \$94__t0 VSS__t134 res_high_po r=542.118769 L=0.5U W=1U
* device instance $174 r0 *1 145.66,8.9 res_high_po
X$174 \$93__t1 \$95__t0 VSS__t135 res_high_po r=542.118769 L=0.5U W=1U
* device instance $175 r0 *1 147.5,8.9 res_high_po
X$175 \$94__t1 \$96__t0 VSS__t136 res_high_po r=542.118769 L=0.5U W=1U
* device instance $176 r0 *1 149.34,8.9 res_high_po
X$176 \$95__t1 \$97__t0 VSS__t137 res_high_po r=542.118769 L=0.5U W=1U
* device instance $177 r0 *1 151.18,8.9 res_high_po
X$177 \$96__t1 \$101__t0 VSS__t138 res_high_po r=542.118769 L=0.5U W=1U
* device instance $178 r0 *1 54.29,10.3 res_high_po
X$178 \$102__t1 \$103__t0 VSS__t94 res_high_po r=2003.841367 L=5U W=1U
* device instance $179 r0 *1 54.29,11.7 res_high_po
X$179 \$98__t1 \$120__t0 VSS__t104 res_high_po r=2003.841367 L=5U W=1U
* device instance $180 r0 *1 60.63,10.3 res_high_po
X$180 \$98__t0 \$104__t0 VSS__t95 res_high_po r=2003.841367 L=5U W=1U
* device instance $181 r0 *1 60.63,11.7 res_high_po
X$181 \$102__t0 \$121__t0 VSS__t105 res_high_po r=2003.841367 L=5U W=1U
* device instance $182 r0 *1 66.97,10.3 res_high_po
X$182 \$103__t1 \$105__t0 VSS__t96 res_high_po r=2003.841367 L=5U W=1U
* device instance $183 r0 *1 66.97,11.7 res_high_po
X$183 \$120__t1 \$122__t0 VSS__t106 res_high_po r=2003.841367 L=5U W=1U
* device instance $184 r0 *1 73.31,11.7 res_high_po
X$184 \$121__t1 \$123__t0 VSS__t107 res_high_po r=2003.841367 L=5U W=1U
* device instance $185 r0 *1 73.31,10.3 res_high_po
X$185 \$104__t1 \$106__t0 VSS__t97 res_high_po r=2003.841367 L=5U W=1U
* device instance $186 r0 *1 79.65,10.3 res_high_po
X$186 \$105__t1 \$107__t0 VSS__t98 res_high_po r=2003.841367 L=5U W=1U
* device instance $187 r0 *1 79.65,11.7 res_high_po
X$187 \$122__t1 \$124__t0 VSS__t108 res_high_po r=2003.841367 L=5U W=1U
* device instance $188 r0 *1 85.99,11.7 res_high_po
X$188 \$123__t1 \$125__t0 VSS__t109 res_high_po r=2003.841367 L=5U W=1U
* device instance $189 r0 *1 85.99,10.3 res_high_po
X$189 \$106__t1 \$108__t0 VSS__t99 res_high_po r=2003.841367 L=5U W=1U
* device instance $190 r0 *1 92.33,11.7 res_high_po
X$190 \$124__t1 \$126__t0 VSS__t110 res_high_po r=2003.841367 L=5U W=1U
* device instance $191 r0 *1 92.33,10.3 res_high_po
X$191 \$107__t1 \$109__t0 VSS__t100 res_high_po r=2003.841367 L=5U W=1U
* device instance $192 r0 *1 98.67,11.7 res_high_po
X$192 \$125__t1 \$127__t0 VSS__t111 res_high_po r=2003.841367 L=5U W=1U
* device instance $193 r0 *1 98.67,10.3 res_high_po
X$193 \$108__t1 \$110__t0 VSS__t101 res_high_po r=2003.841367 L=5U W=1U
* device instance $194 r0 *1 105.01,10.3 res_high_po
X$194 \$109__t1 \$99__t0 VSS__t102 res_high_po r=2003.841367 L=5U W=1U
* device instance $195 r0 *1 105.01,11.7 res_high_po
X$195 \$126__t1 \$128__t0 VSS__t112 res_high_po r=2003.841367 L=5U W=1U
* device instance $196 r0 *1 111.35,10.3 res_high_po
X$196 \$110__t1 \$86__t0 VSS__t103 res_high_po r=2003.841367 L=5U W=1U
* device instance $197 r0 *1 111.35,11.7 res_high_po
X$197 \$127__t1 \$129__t0 VSS__t113 res_high_po r=2003.841367 L=5U W=1U
* device instance $198 r0 *1 134.62,11.7 res_high_po
X$198 \$100__t0 \$130__t0 VSS__t149 res_high_po r=542.118769 L=0.5U W=1U
* device instance $199 r0 *1 134.62,10.3 res_high_po
X$199 \$111__t0 \$112__t0 VSS__t139 res_high_po r=542.118769 L=0.5U W=1U
* device instance $200 r0 *1 136.46,10.3 res_high_po
X$200 \$100__t1 \$113__t0 VSS__t140 res_high_po r=542.118769 L=0.5U W=1U
* device instance $201 r0 *1 136.46,11.7 res_high_po
X$201 \$111__t1 \$131__t0 VSS__t150 res_high_po r=542.118769 L=0.5U W=1U
* device instance $202 r0 *1 138.3,10.3 res_high_po
X$202 \$112__t1 \$114__t0 VSS__t141 res_high_po r=542.118769 L=0.5U W=1U
* device instance $203 r0 *1 138.3,11.7 res_high_po
X$203 \$130__t1 \$132__t0 VSS__t151 res_high_po r=542.118769 L=0.5U W=1U
* device instance $204 r0 *1 140.14,10.3 res_high_po
X$204 \$113__t1 \$115__t0 VSS__t142 res_high_po r=542.118769 L=0.5U W=1U
* device instance $205 r0 *1 140.14,11.7 res_high_po
X$205 \$131__t1 \$133__t0 VSS__t152 res_high_po r=542.118769 L=0.5U W=1U
* device instance $206 r0 *1 141.98,11.7 res_high_po
X$206 \$132__t1 \$134__t0 VSS__t153 res_high_po r=542.118769 L=0.5U W=1U
* device instance $207 r0 *1 141.98,10.3 res_high_po
X$207 \$114__t1 \$116__t0 VSS__t143 res_high_po r=542.118769 L=0.5U W=1U
* device instance $208 r0 *1 143.82,11.7 res_high_po
X$208 \$133__t1 \$135__t0 VSS__t154 res_high_po r=542.118769 L=0.5U W=1U
* device instance $209 r0 *1 143.82,10.3 res_high_po
X$209 \$115__t1 \$117__t0 VSS__t144 res_high_po r=542.118769 L=0.5U W=1U
* device instance $210 r0 *1 145.66,10.3 res_high_po
X$210 \$116__t1 \$118__t0 VSS__t145 res_high_po r=542.118769 L=0.5U W=1U
* device instance $211 r0 *1 145.66,11.7 res_high_po
X$211 \$134__t1 \$136__t0 VSS__t155 res_high_po r=542.118769 L=0.5U W=1U
* device instance $212 r0 *1 147.5,11.7 res_high_po
X$212 \$135__t1 \$137__t0 VSS__t156 res_high_po r=542.118769 L=0.5U W=1U
* device instance $213 r0 *1 147.5,10.3 res_high_po
X$213 \$117__t1 \$119__t0 VSS__t146 res_high_po r=542.118769 L=0.5U W=1U
* device instance $214 r0 *1 149.34,11.7 res_high_po
X$214 \$136__t1 \$138__t0 VSS__t157 res_high_po r=542.118769 L=0.5U W=1U
* device instance $215 r0 *1 149.34,10.3 res_high_po
X$215 \$118__t1 \$101__t1 VSS__t147 res_high_po r=542.118769 L=0.5U W=1U
* device instance $216 r0 *1 151.18,11.7 res_high_po
X$216 \$137__t1 \$139__t0 VSS__t158 res_high_po r=542.118769 L=0.5U W=1U
* device instance $217 r0 *1 151.18,10.3 res_high_po
X$217 \$119__t1 \$97__t1 VSS__t148 res_high_po r=542.118769 L=0.5U W=1U
* device instance $218 r0 *1 66.97,13.1 res_high_po
X$218 \$168__t1 \$142__t0 VSS__t114 res_high_po r=2003.841367 L=5U W=1U
* device instance $219 r0 *1 73.31,13.1 res_high_po
X$219 \$2__t1 \$143__t0 VSS__t115 res_high_po r=2003.841367 L=5U W=1U
* device instance $220 r0 *1 79.65,13.1 res_high_po
X$220 \$142__t1 \$144__t0 VSS__t116 res_high_po r=2003.841367 L=5U W=1U
* device instance $221 r0 *1 85.99,13.1 res_high_po
X$221 \$143__t1 \$145__t0 VSS__t117 res_high_po r=2003.841367 L=5U W=1U
* device instance $222 r0 *1 92.33,13.1 res_high_po
X$222 \$144__t1 \$146__t0 VSS__t118 res_high_po r=2003.841367 L=5U W=1U
* device instance $223 r0 *1 98.67,13.1 res_high_po
X$223 \$145__t1 \$147__t0 VSS__t119 res_high_po r=2003.841367 L=5U W=1U
* device instance $224 r0 *1 105.01,13.1 res_high_po
X$224 \$146__t1 \$129__t1 VSS__t120 res_high_po r=2003.841367 L=5U W=1U
* device instance $225 r0 *1 111.35,13.1 res_high_po
X$225 \$147__t1 \$128__t1 VSS__t121 res_high_po r=2003.841367 L=5U W=1U
* device instance $226 r0 *1 134.62,13.1 res_high_po
X$226 VB__t8 \$150__t0 VSS__t159 res_high_po r=542.118769 L=0.5U W=1U
* device instance $227 r0 *1 136.46,13.1 res_high_po
X$227 VA__t9 \$151__t0 VSS__t160 res_high_po r=542.118769 L=0.5U W=1U
* device instance $228 r0 *1 138.3,13.1 res_high_po
X$228 \$150__t1 \$152__t0 VSS__t161 res_high_po r=542.118769 L=0.5U W=1U
* device instance $229 r0 *1 140.14,13.1 res_high_po
X$229 \$151__t1 \$153__t0 VSS__t162 res_high_po r=542.118769 L=0.5U W=1U
* device instance $230 r0 *1 141.98,13.1 res_high_po
X$230 \$152__t1 \$154__t0 VSS__t163 res_high_po r=542.118769 L=0.5U W=1U
* device instance $231 r0 *1 143.82,13.1 res_high_po
X$231 \$153__t1 \$155__t0 VSS__t164 res_high_po r=542.118769 L=0.5U W=1U
* device instance $232 r0 *1 145.66,13.1 res_high_po
X$232 \$154__t1 \$156__t0 VSS__t165 res_high_po r=542.118769 L=0.5U W=1U
* device instance $233 r0 *1 147.5,13.1 res_high_po
X$233 \$155__t1 \$157__t0 VSS__t166 res_high_po r=542.118769 L=0.5U W=1U
* device instance $234 r0 *1 149.34,13.1 res_high_po
X$234 \$156__t1 \$139__t1 VSS__t167 res_high_po r=542.118769 L=0.5U W=1U
* device instance $235 r0 *1 151.18,13.1 res_high_po
X$235 \$157__t1 \$138__t1 VSS__t168 res_high_po r=542.118769 L=0.5U W=1U
* device instance $236 r0 *1 183.45,13.1 res_high_po
X$236 VB__t9 \$160__t0 VSS__t122 res_high_po r=2003.841367 L=5U W=1U
* device instance $237 r0 *1 189.79,13.1 res_high_po
X$237 \$160__t1 \$161__t0 VSS__t123 res_high_po r=2003.841367 L=5U W=1U
* device instance $238 r0 *1 196.13,13.1 res_high_po
X$238 \$161__t1 \$162__t0 VSS__t124 res_high_po r=2003.841367 L=5U W=1U
* device instance $239 r0 *1 202.47,13.1 res_high_po
X$239 \$162__t1 \$163__t0 VSS__t125 res_high_po r=2003.841367 L=5U W=1U
* device instance $240 r0 *1 208.81,13.1 res_high_po
X$240 \$163__t1 \$164__t0 VSS__t126 res_high_po r=2003.841367 L=5U W=1U
* device instance $241 r0 *1 215.15,13.1 res_high_po
X$241 \$164__t1 \$165__t0 VSS__t127 res_high_po r=2003.841367 L=5U W=1U
* device instance $242 r0 *1 221.49,13.1 res_high_po
X$242 \$165__t1 VBQ__t8 VSS__t128 res_high_po r=2003.841367 L=5U W=1U
* device instance _10_t0 r0 *1 0,0
R_10_t0 \$10__t0 \$10 52.6733
* device instance _10_t1 r0 *1 0,0
R_10_t1 \$10__t1 \$10 52.6733
* device instance _10 r0 *1 0,0
C_10 \$10 vsubs 1.327841e-15
* device instance _100_t0 r0 *1 0,0
R_100_t0 \$100__t0 \$100 54.206
* device instance _100_t1 r0 *1 0,0
R_100_t1 \$100__t1 \$100 54.206
* device instance _100 r0 *1 0,0
C_100 \$100 vsubs 1.833833e-15
* device instance _101_t0 r0 *1 0,0
R_101_t0 \$101__t0 \$101 51.6636
* device instance _101_t1 r0 *1 0,0
R_101_t1 \$101__t1 \$101 51.6636
* device instance _101 r0 *1 0,0
C_101 \$101 vsubs 9.78642e-16
* device instance _102_t0 r0 *1 0,0
R_102_t0 \$102__t0 \$102 52.84925
* device instance _102_t1 r0 *1 0,0
R_102_t1 \$102__t1 \$102 52.84925
* device instance _102 r0 *1 0,0
C_102 \$102 vsubs 1.371243e-15
* device instance _103_t0 r0 *1 0,0
R_103_t0 \$103__t0 \$103 52.6733
* device instance _103_t1 r0 *1 0,0
R_103_t1 \$103__t1 \$103 52.6733
* device instance _103 r0 *1 0,0
C_103 \$103 vsubs 1.327841e-15
* device instance _104_t0 r0 *1 0,0
R_104_t0 \$104__t0 \$104 52.6733
* device instance _104_t1 r0 *1 0,0
R_104_t1 \$104__t1 \$104 52.6733
* device instance _104 r0 *1 0,0
C_104 \$104 vsubs 1.327841e-15
* device instance _105_t0 r0 *1 0,0
R_105_t0 \$105__t0 \$105 52.6733
* device instance _105_t1 r0 *1 0,0
R_105_t1 \$105__t1 \$105 52.6733
* device instance _105 r0 *1 0,0
C_105 \$105 vsubs 1.327841e-15
* device instance _106_t0 r0 *1 0,0
R_106_t0 \$106__t0 \$106 52.6733
* device instance _106_t1 r0 *1 0,0
R_106_t1 \$106__t1 \$106 52.6733
* device instance _106 r0 *1 0,0
C_106 \$106 vsubs 1.327841e-15
* device instance _107_t0 r0 *1 0,0
R_107_t0 \$107__t0 \$107 52.6733
* device instance _107_t1 r0 *1 0,0
R_107_t1 \$107__t1 \$107 52.6733
* device instance _107 r0 *1 0,0
C_107 \$107 vsubs 1.327841e-15
* device instance _108_t0 r0 *1 0,0
R_108_t0 \$108__t0 \$108 52.6733
* device instance _108_t1 r0 *1 0,0
R_108_t1 \$108__t1 \$108 52.6733
* device instance _108 r0 *1 0,0
C_108 \$108 vsubs 1.327841e-15
* device instance _109_t0 r0 *1 0,0
R_109_t0 \$109__t0 \$109 52.6733
* device instance _109_t1 r0 *1 0,0
R_109_t1 \$109__t1 \$109 52.6733
* device instance _109 r0 *1 0,0
C_109 \$109 vsubs 1.327841e-15
* device instance _11_t0 r0 *1 0,0
R_11_t0 \$11__t0 \$11 52.6733
* device instance _11_t1 r0 *1 0,0
R_11_t1 \$11__t1 \$11 52.6733
* device instance _11 r0 *1 0,0
C_11 \$11 vsubs 1.327841e-15
* device instance _110_t0 r0 *1 0,0
R_110_t0 \$110__t0 \$110 52.6733
* device instance _110_t1 r0 *1 0,0
R_110_t1 \$110__t1 \$110 52.6733
* device instance _110 r0 *1 0,0
C_110 \$110 vsubs 1.33157e-15
* device instance _111_t0 r0 *1 0,0
R_111_t0 \$111__t0 \$111 51.6636
* device instance _111_t1 r0 *1 0,0
R_111_t1 \$111__t1 \$111 51.6636
* device instance _111 r0 *1 0,0
C_111 \$111 vsubs 9.78642e-16
* device instance _112_t0 r0 *1 0,0
R_112_t0 \$112__t0 \$112 51.50145
* device instance _112_t1 r0 *1 0,0
R_112_t1 \$112__t1 \$112 51.50145
* device instance _112 r0 *1 0,0
C_112 \$112 vsubs 9.34868e-16
* device instance _113_t0 r0 *1 0,0
R_113_t0 \$113__t0 \$113 51.50145
* device instance _113_t1 r0 *1 0,0
R_113_t1 \$113__t1 \$113 51.50145
* device instance _113 r0 *1 0,0
C_113 \$113 vsubs 9.34868e-16
* device instance _114_t0 r0 *1 0,0
R_114_t0 \$114__t0 \$114 51.50145
* device instance _114_t1 r0 *1 0,0
R_114_t1 \$114__t1 \$114 51.50145
* device instance _114 r0 *1 0,0
C_114 \$114 vsubs 9.34868e-16
* device instance _115_t0 r0 *1 0,0
R_115_t0 \$115__t0 \$115 51.50145
* device instance _115_t1 r0 *1 0,0
R_115_t1 \$115__t1 \$115 51.50145
* device instance _115 r0 *1 0,0
C_115 \$115 vsubs 9.34868e-16
* device instance _116_t0 r0 *1 0,0
R_116_t0 \$116__t0 \$116 51.50145
* device instance _116_t1 r0 *1 0,0
R_116_t1 \$116__t1 \$116 51.50145
* device instance _116 r0 *1 0,0
C_116 \$116 vsubs 9.34868e-16
* device instance _117_t0 r0 *1 0,0
R_117_t0 \$117__t0 \$117 51.50145
* device instance _117_t1 r0 *1 0,0
R_117_t1 \$117__t1 \$117 51.50145
* device instance _117 r0 *1 0,0
C_117 \$117 vsubs 9.34868e-16
* device instance _118_t0 r0 *1 0,0
R_118_t0 \$118__t0 \$118 51.50145
* device instance _118_t1 r0 *1 0,0
R_118_t1 \$118__t1 \$118 51.50145
* device instance _118 r0 *1 0,0
C_118 \$118 vsubs 9.34868e-16
* device instance _119_t0 r0 *1 0,0
R_119_t0 \$119__t0 \$119 51.50145
* device instance _119_t1 r0 *1 0,0
R_119_t1 \$119__t1 \$119 51.50145
* device instance _119 r0 *1 0,0
C_119 \$119 vsubs 9.34868e-16
* device instance _12_t0 r0 *1 0,0
R_12_t0 \$12__t0 \$12 52.6733
* device instance _12_t1 r0 *1 0,0
R_12_t1 \$12__t1 \$12 52.6733
* device instance _12 r0 *1 0,0
C_12 \$12 vsubs 1.327841e-15
* device instance _120_t0 r0 *1 0,0
R_120_t0 \$120__t0 \$120 52.6733
* device instance _120_t1 r0 *1 0,0
R_120_t1 \$120__t1 \$120 52.6733
* device instance _120 r0 *1 0,0
C_120 \$120 vsubs 1.327841e-15
* device instance _121_t0 r0 *1 0,0
R_121_t0 \$121__t0 \$121 52.6733
* device instance _121_t1 r0 *1 0,0
R_121_t1 \$121__t1 \$121 52.6733
* device instance _121 r0 *1 0,0
C_121 \$121 vsubs 1.327841e-15
* device instance _122_t0 r0 *1 0,0
R_122_t0 \$122__t0 \$122 52.6733
* device instance _122_t1 r0 *1 0,0
R_122_t1 \$122__t1 \$122 52.6733
* device instance _122 r0 *1 0,0
C_122 \$122 vsubs 1.327841e-15
* device instance _123_t0 r0 *1 0,0
R_123_t0 \$123__t0 \$123 52.6733
* device instance _123_t1 r0 *1 0,0
R_123_t1 \$123__t1 \$123 52.6733
* device instance _123 r0 *1 0,0
C_123 \$123 vsubs 1.327841e-15
* device instance _124_t0 r0 *1 0,0
R_124_t0 \$124__t0 \$124 52.6733
* device instance _124_t1 r0 *1 0,0
R_124_t1 \$124__t1 \$124 52.6733
* device instance _124 r0 *1 0,0
C_124 \$124 vsubs 1.327841e-15
* device instance _125_t0 r0 *1 0,0
R_125_t0 \$125__t0 \$125 52.6733
* device instance _125_t1 r0 *1 0,0
R_125_t1 \$125__t1 \$125 52.6733
* device instance _125 r0 *1 0,0
C_125 \$125 vsubs 1.327841e-15
* device instance _126_t0 r0 *1 0,0
R_126_t0 \$126__t0 \$126 52.6733
* device instance _126_t1 r0 *1 0,0
R_126_t1 \$126__t1 \$126 52.6733
* device instance _126 r0 *1 0,0
C_126 \$126 vsubs 1.327841e-15
* device instance _127_t0 r0 *1 0,0
R_127_t0 \$127__t0 \$127 52.6733
* device instance _127_t1 r0 *1 0,0
R_127_t1 \$127__t1 \$127 52.6733
* device instance _127 r0 *1 0,0
C_127 \$127 vsubs 1.327841e-15
* device instance _128_t0 r0 *1 0,0
R_128_t0 \$128__t0 \$128 53.46165
* device instance _128_t1 r0 *1 0,0
R_128_t1 \$128__t1 \$128 53.46165
* device instance _128 r0 *1 0,0
C_128 \$128 vsubs 1.584077e-15
* device instance _129_t0 r0 *1 0,0
R_129_t0 \$129__t0 \$129 53.0572
* device instance _129_t1 r0 *1 0,0
R_129_t1 \$129__t1 \$129 53.0572
* device instance _129 r0 *1 0,0
C_129 \$129 vsubs 1.443703e-15
* device instance _13_t0 r0 *1 0,0
R_13_t0 \$13__t0 \$13 52.6733
* device instance _13_t1 r0 *1 0,0
R_13_t1 \$13__t1 \$13 52.6733
* device instance _13 r0 *1 0,0
C_13 \$13 vsubs 1.327841e-15
* device instance _130_t0 r0 *1 0,0
R_130_t0 \$130__t0 \$130 51.50145
* device instance _130_t1 r0 *1 0,0
R_130_t1 \$130__t1 \$130 51.50145
* device instance _130 r0 *1 0,0
C_130 \$130 vsubs 9.34868e-16
* device instance _131_t0 r0 *1 0,0
R_131_t0 \$131__t0 \$131 51.50145
* device instance _131_t1 r0 *1 0,0
R_131_t1 \$131__t1 \$131 51.50145
* device instance _131 r0 *1 0,0
C_131 \$131 vsubs 9.34868e-16
* device instance _132_t0 r0 *1 0,0
R_132_t0 \$132__t0 \$132 51.50145
* device instance _132_t1 r0 *1 0,0
R_132_t1 \$132__t1 \$132 51.50145
* device instance _132 r0 *1 0,0
C_132 \$132 vsubs 9.34868e-16
* device instance _133_t0 r0 *1 0,0
R_133_t0 \$133__t0 \$133 51.50145
* device instance _133_t1 r0 *1 0,0
R_133_t1 \$133__t1 \$133 51.50145
* device instance _133 r0 *1 0,0
C_133 \$133 vsubs 9.34868e-16
* device instance _134_t0 r0 *1 0,0
R_134_t0 \$134__t0 \$134 51.50145
* device instance _134_t1 r0 *1 0,0
R_134_t1 \$134__t1 \$134 51.50145
* device instance _134 r0 *1 0,0
C_134 \$134 vsubs 9.34868e-16
* device instance _135_t0 r0 *1 0,0
R_135_t0 \$135__t0 \$135 51.50145
* device instance _135_t1 r0 *1 0,0
R_135_t1 \$135__t1 \$135 51.50145
* device instance _135 r0 *1 0,0
C_135 \$135 vsubs 9.34868e-16
* device instance _136_t0 r0 *1 0,0
R_136_t0 \$136__t0 \$136 51.50145
* device instance _136_t1 r0 *1 0,0
R_136_t1 \$136__t1 \$136 51.50145
* device instance _136 r0 *1 0,0
C_136 \$136 vsubs 9.34868e-16
* device instance _137_t0 r0 *1 0,0
R_137_t0 \$137__t0 \$137 51.50145
* device instance _137_t1 r0 *1 0,0
R_137_t1 \$137__t1 \$137 51.50145
* device instance _137 r0 *1 0,0
C_137 \$137 vsubs 9.34868e-16
* device instance _138_t0 r0 *1 0,0
R_138_t0 \$138__t0 \$138 52.29125
* device instance _138_t1 r0 *1 0,0
R_138_t1 \$138__t1 \$138 52.29125
* device instance _138 r0 *1 0,0
C_138 \$138 vsubs 1.182257e-15
* device instance _139_t0 r0 *1 0,0
R_139_t0 \$139__t0 \$139 51.6636
* device instance _139_t1 r0 *1 0,0
R_139_t1 \$139__t1 \$139 51.6636
* device instance _139 r0 *1 0,0
C_139 \$139 vsubs 9.76662e-16
* device instance _14_t0 r0 *1 0,0
R_14_t0 \$14__t0 \$14 52.6733
* device instance _14_t1 r0 *1 0,0
R_14_t1 \$14__t1 \$14 52.6733
* device instance _14 r0 *1 0,0
C_14 \$14 vsubs 1.327841e-15
* device instance _142_t0 r0 *1 0,0
R_142_t0 \$142__t0 \$142 52.6733
* device instance _142_t1 r0 *1 0,0
R_142_t1 \$142__t1 \$142 52.6733
* device instance _142 r0 *1 0,0
C_142 \$142 vsubs 1.327841e-15
* device instance _143_t0 r0 *1 0,0
R_143_t0 \$143__t0 \$143 52.6733
* device instance _143_t1 r0 *1 0,0
R_143_t1 \$143__t1 \$143 52.6733
* device instance _143 r0 *1 0,0
C_143 \$143 vsubs 1.327841e-15
* device instance _144_t0 r0 *1 0,0
R_144_t0 \$144__t0 \$144 52.6733
* device instance _144_t1 r0 *1 0,0
R_144_t1 \$144__t1 \$144 52.6733
* device instance _144 r0 *1 0,0
C_144 \$144 vsubs 1.327841e-15
* device instance _145_t0 r0 *1 0,0
R_145_t0 \$145__t0 \$145 52.6733
* device instance _145_t1 r0 *1 0,0
R_145_t1 \$145__t1 \$145 52.6733
* device instance _145 r0 *1 0,0
C_145 \$145 vsubs 1.327841e-15
* device instance _146_t0 r0 *1 0,0
R_146_t0 \$146__t0 \$146 52.6733
* device instance _146_t1 r0 *1 0,0
R_146_t1 \$146__t1 \$146 52.6733
* device instance _146 r0 *1 0,0
C_146 \$146 vsubs 1.327841e-15
* device instance _147_t0 r0 *1 0,0
R_147_t0 \$147__t0 \$147 52.6733
* device instance _147_t1 r0 *1 0,0
R_147_t1 \$147__t1 \$147 52.6733
* device instance _147 r0 *1 0,0
C_147 \$147 vsubs 1.33157e-15
* device instance _15_t0 r0 *1 0,0
R_15_t0 \$15__t0 \$15 53.46165
* device instance _15_t1 r0 *1 0,0
R_15_t1 \$15__t1 \$15 53.46165
* device instance _15 r0 *1 0,0
C_15 \$15 vsubs 1.584077e-15
* device instance _150_t0 r0 *1 0,0
R_150_t0 \$150__t0 \$150 51.50145
* device instance _150_t1 r0 *1 0,0
R_150_t1 \$150__t1 \$150 51.50145
* device instance _150 r0 *1 0,0
C_150 \$150 vsubs 9.34868e-16
* device instance _151_t0 r0 *1 0,0
R_151_t0 \$151__t0 \$151 51.50145
* device instance _151_t1 r0 *1 0,0
R_151_t1 \$151__t1 \$151 51.50145
* device instance _151 r0 *1 0,0
C_151 \$151 vsubs 9.21504e-16
* device instance _152_t0 r0 *1 0,0
R_152_t0 \$152__t0 \$152 51.50145
* device instance _152_t1 r0 *1 0,0
R_152_t1 \$152__t1 \$152 51.50145
* device instance _152 r0 *1 0,0
C_152 \$152 vsubs 9.34868e-16
* device instance _153_t0 r0 *1 0,0
R_153_t0 \$153__t0 \$153 51.50145
* device instance _153_t1 r0 *1 0,0
R_153_t1 \$153__t1 \$153 51.50145
* device instance _153 r0 *1 0,0
C_153 \$153 vsubs 9.21504e-16
* device instance _154_t0 r0 *1 0,0
R_154_t0 \$154__t0 \$154 51.50145
* device instance _154_t1 r0 *1 0,0
R_154_t1 \$154__t1 \$154 51.50145
* device instance _154 r0 *1 0,0
C_154 \$154 vsubs 9.34868e-16
* device instance _155_t0 r0 *1 0,0
R_155_t0 \$155__t0 \$155 51.50145
* device instance _155_t1 r0 *1 0,0
R_155_t1 \$155__t1 \$155 51.50145
* device instance _155 r0 *1 0,0
C_155 \$155 vsubs 9.21504e-16
* device instance _156_t0 r0 *1 0,0
R_156_t0 \$156__t0 \$156 51.50145
* device instance _156_t1 r0 *1 0,0
R_156_t1 \$156__t1 \$156 51.50145
* device instance _156 r0 *1 0,0
C_156 \$156 vsubs 9.34868e-16
* device instance _157_t0 r0 *1 0,0
R_157_t0 \$157__t0 \$157 51.50145
* device instance _157_t1 r0 *1 0,0
R_157_t1 \$157__t1 \$157 51.50145
* device instance _157 r0 *1 0,0
C_157 \$157 vsubs 9.21504e-16
* device instance _16_t0 r0 *1 0,0
R_16_t0 \$16__t0 \$16 53.0572
* device instance _16_t1 r0 *1 0,0
R_16_t1 \$16__t1 \$16 53.0572
* device instance _16 r0 *1 0,0
C_16 \$16 vsubs 1.443703e-15
* device instance _160_t0 r0 *1 0,0
R_160_t0 \$160__t0 \$160 51.02225
* device instance _160_t1 r0 *1 0,0
R_160_t1 \$160__t1 \$160 51.02225
* device instance _160 r0 *1 0,0
C_160 \$160 vsubs 7.86843e-16
* device instance _161_t0 r0 *1 0,0
R_161_t0 \$161__t0 \$161 51.02225
* device instance _161_t1 r0 *1 0,0
R_161_t1 \$161__t1 \$161 51.02225
* device instance _161 r0 *1 0,0
C_161 \$161 vsubs 7.86843e-16
* device instance _162_t0 r0 *1 0,0
R_162_t0 \$162__t0 \$162 51.02225
* device instance _162_t1 r0 *1 0,0
R_162_t1 \$162__t1 \$162 51.02225
* device instance _162 r0 *1 0,0
C_162 \$162 vsubs 7.86843e-16
* device instance _163_t0 r0 *1 0,0
R_163_t0 \$163__t0 \$163 51.02225
* device instance _163_t1 r0 *1 0,0
R_163_t1 \$163__t1 \$163 51.02225
* device instance _163 r0 *1 0,0
C_163 \$163 vsubs 7.86843e-16
* device instance _164_t0 r0 *1 0,0
R_164_t0 \$164__t0 \$164 51.02225
* device instance _164_t1 r0 *1 0,0
R_164_t1 \$164__t1 \$164 51.02225
* device instance _164 r0 *1 0,0
C_164 \$164 vsubs 7.86843e-16
* device instance _165_t0 r0 *1 0,0
R_165_t0 \$165__t0 \$165 51.02225
* device instance _165_t1 r0 *1 0,0
R_165_t1 \$165__t1 \$165 51.02225
* device instance _165 r0 *1 0,0
C_165 \$165 vsubs 7.86843e-16
* device instance _168_t0 r0 *1 0,0
R_168_t0 \$168__t0 \$168 86.335
* device instance _168_t1 r0 *1 0,0
R_168_t1 \$168__t1 \$168 86.335
* device instance _168 r0 *1 0,0
C_168 \$168 vsubs 1.2594962e-14
* device instance _182_t0 r0 *1 0,0
R_182_t0 \$182__t0 \$182 45.3013
* device instance _182_t1 r0 *1 0,0
R_182_t1 \$182__t1 \$182 45.3013
* device instance _182_t2 r0 *1 0,0
R_182_t2 \$182__t2 \$182 90.6026
* device instance _182 r0 *1 0,0
C_182 \$182 vsubs 4.937046e-15
* device instance _2_t0 r0 *1 0,0
R_2_t0 \$2__t0 \$2 93.65275
* device instance _2_t1 r0 *1 0,0
R_2_t1 \$2__t1 \$2 93.65275
* device instance _2 r0 *1 0,0
C_2 \$2 vsubs 1.5041266e-14
* device instance _21_t0 r0 *1 0,0
R_21_t0 \$21__t0 \$21 60.06445
* device instance _21_t1 r0 *1 0,0
R_21_t1 \$21__t1 \$21 60.06445
* device instance _21 r0 *1 0,0
C_21 \$21 vsubs 3.794735e-15
* device instance _22_t0 r0 *1 0,0
R_22_t0 \$22__t0 \$22 52.84925
* device instance _22_t1 r0 *1 0,0
R_22_t1 \$22__t1 \$22 52.84925
* device instance _22 r0 *1 0,0
C_22 \$22 vsubs 1.371243e-15
* device instance _23_t0 r0 *1 0,0
R_23_t0 \$23__t0 \$23 52.6733
* device instance _23_t1 r0 *1 0,0
R_23_t1 \$23__t1 \$23 52.6733
* device instance _23 r0 *1 0,0
C_23 \$23 vsubs 1.327841e-15
* device instance _24_t0 r0 *1 0,0
R_24_t0 \$24__t0 \$24 52.6733
* device instance _24_t1 r0 *1 0,0
R_24_t1 \$24__t1 \$24 52.6733
* device instance _24 r0 *1 0,0
C_24 \$24 vsubs 1.327841e-15
* device instance _25_t0 r0 *1 0,0
R_25_t0 \$25__t0 \$25 52.6733
* device instance _25_t1 r0 *1 0,0
R_25_t1 \$25__t1 \$25 52.6733
* device instance _25 r0 *1 0,0
C_25 \$25 vsubs 1.327841e-15
* device instance _26_t0 r0 *1 0,0
R_26_t0 \$26__t0 \$26 52.6733
* device instance _26_t1 r0 *1 0,0
R_26_t1 \$26__t1 \$26 52.6733
* device instance _26 r0 *1 0,0
C_26 \$26 vsubs 1.327841e-15
* device instance _27_t0 r0 *1 0,0
R_27_t0 \$27__t0 \$27 52.6733
* device instance _27_t1 r0 *1 0,0
R_27_t1 \$27__t1 \$27 52.6733
* device instance _27 r0 *1 0,0
C_27 \$27 vsubs 1.327841e-15
* device instance _28_t0 r0 *1 0,0
R_28_t0 \$28__t0 \$28 52.6733
* device instance _28_t1 r0 *1 0,0
R_28_t1 \$28__t1 \$28 52.6733
* device instance _28 r0 *1 0,0
C_28 \$28 vsubs 1.327841e-15
* device instance _29_t0 r0 *1 0,0
R_29_t0 \$29__t0 \$29 52.6733
* device instance _29_t1 r0 *1 0,0
R_29_t1 \$29__t1 \$29 52.6733
* device instance _29 r0 *1 0,0
C_29 \$29 vsubs 1.327841e-15
* device instance _30_t0 r0 *1 0,0
R_30_t0 \$30__t0 \$30 52.6733
* device instance _30_t1 r0 *1 0,0
R_30_t1 \$30__t1 \$30 52.6733
* device instance _30 r0 *1 0,0
C_30 \$30 vsubs 1.33157e-15
* device instance _36_t0 r0 *1 0,0
R_36_t0 \$36__t0 \$36 52.6733
* device instance _36_t1 r0 *1 0,0
R_36_t1 \$36__t1 \$36 52.6733
* device instance _36 r0 *1 0,0
C_36 \$36 vsubs 1.327841e-15
* device instance _37_t0 r0 *1 0,0
R_37_t0 \$37__t0 \$37 52.6733
* device instance _37_t1 r0 *1 0,0
R_37_t1 \$37__t1 \$37 52.6733
* device instance _37 r0 *1 0,0
C_37 \$37 vsubs 1.327841e-15
* device instance _38_t0 r0 *1 0,0
R_38_t0 \$38__t0 \$38 52.6733
* device instance _38_t1 r0 *1 0,0
R_38_t1 \$38__t1 \$38 52.6733
* device instance _38 r0 *1 0,0
C_38 \$38 vsubs 1.327841e-15
* device instance _39_t0 r0 *1 0,0
R_39_t0 \$39__t0 \$39 52.6733
* device instance _39_t1 r0 *1 0,0
R_39_t1 \$39__t1 \$39 52.6733
* device instance _39 r0 *1 0,0
C_39 \$39 vsubs 1.327841e-15
* device instance _40_t0 r0 *1 0,0
R_40_t0 \$40__t0 \$40 52.6733
* device instance _40_t1 r0 *1 0,0
R_40_t1 \$40__t1 \$40 52.6733
* device instance _40 r0 *1 0,0
C_40 \$40 vsubs 1.327841e-15
* device instance _41_t0 r0 *1 0,0
R_41_t0 \$41__t0 \$41 52.6733
* device instance _41_t1 r0 *1 0,0
R_41_t1 \$41__t1 \$41 52.6733
* device instance _41 r0 *1 0,0
C_41 \$41 vsubs 1.327841e-15
* device instance _42_t0 r0 *1 0,0
R_42_t0 \$42__t0 \$42 52.6733
* device instance _42_t1 r0 *1 0,0
R_42_t1 \$42__t1 \$42 52.6733
* device instance _42 r0 *1 0,0
C_42 \$42 vsubs 1.327841e-15
* device instance _43_t0 r0 *1 0,0
R_43_t0 \$43__t0 \$43 52.6733
* device instance _43_t1 r0 *1 0,0
R_43_t1 \$43__t1 \$43 52.6733
* device instance _43 r0 *1 0,0
C_43 \$43 vsubs 1.327841e-15
* device instance _44_t0 r0 *1 0,0
R_44_t0 \$44__t0 \$44 53.46165
* device instance _44_t1 r0 *1 0,0
R_44_t1 \$44__t1 \$44 53.46165
* device instance _44 r0 *1 0,0
C_44 \$44 vsubs 1.584077e-15
* device instance _45_t0 r0 *1 0,0
R_45_t0 \$45__t0 \$45 53.0572
* device instance _45_t1 r0 *1 0,0
R_45_t1 \$45__t1 \$45 53.0572
* device instance _45 r0 *1 0,0
C_45 \$45 vsubs 1.443703e-15
* device instance _46_t0 r0 *1 0,0
R_46_t0 \$46__t0 \$46 60.06445
* device instance _46_t1 r0 *1 0,0
R_46_t1 \$46__t1 \$46 60.06445
* device instance _46 r0 *1 0,0
C_46 \$46 vsubs 3.794735e-15
* device instance _47_t0 r0 *1 0,0
R_47_t0 \$47__t0 \$47 52.84925
* device instance _47_t1 r0 *1 0,0
R_47_t1 \$47__t1 \$47 52.84925
* device instance _47 r0 *1 0,0
C_47 \$47 vsubs 1.371243e-15
* device instance _48_t0 r0 *1 0,0
R_48_t0 \$48__t0 \$48 52.6733
* device instance _48_t1 r0 *1 0,0
R_48_t1 \$48__t1 \$48 52.6733
* device instance _48 r0 *1 0,0
C_48 \$48 vsubs 1.327841e-15
* device instance _49_t0 r0 *1 0,0
R_49_t0 \$49__t0 \$49 52.6733
* device instance _49_t1 r0 *1 0,0
R_49_t1 \$49__t1 \$49 52.6733
* device instance _49 r0 *1 0,0
C_49 \$49 vsubs 1.327841e-15
* device instance _50_t0 r0 *1 0,0
R_50_t0 \$50__t0 \$50 52.6733
* device instance _50_t1 r0 *1 0,0
R_50_t1 \$50__t1 \$50 52.6733
* device instance _50 r0 *1 0,0
C_50 \$50 vsubs 1.327841e-15
* device instance _51_t0 r0 *1 0,0
R_51_t0 \$51__t0 \$51 52.6733
* device instance _51_t1 r0 *1 0,0
R_51_t1 \$51__t1 \$51 52.6733
* device instance _51 r0 *1 0,0
C_51 \$51 vsubs 1.327841e-15
* device instance _52_t0 r0 *1 0,0
R_52_t0 \$52__t0 \$52 52.6733
* device instance _52_t1 r0 *1 0,0
R_52_t1 \$52__t1 \$52 52.6733
* device instance _52 r0 *1 0,0
C_52 \$52 vsubs 1.327841e-15
* device instance _53_t0 r0 *1 0,0
R_53_t0 \$53__t0 \$53 52.6733
* device instance _53_t1 r0 *1 0,0
R_53_t1 \$53__t1 \$53 52.6733
* device instance _53 r0 *1 0,0
C_53 \$53 vsubs 1.327841e-15
* device instance _54_t0 r0 *1 0,0
R_54_t0 \$54__t0 \$54 52.6733
* device instance _54_t1 r0 *1 0,0
R_54_t1 \$54__t1 \$54 52.6733
* device instance _54 r0 *1 0,0
C_54 \$54 vsubs 1.327841e-15
* device instance _55_t0 r0 *1 0,0
R_55_t0 \$55__t0 \$55 52.6733
* device instance _55_t1 r0 *1 0,0
R_55_t1 \$55__t1 \$55 52.6733
* device instance _55 r0 *1 0,0
C_55 \$55 vsubs 1.33157e-15
* device instance _56_t0 r0 *1 0,0
R_56_t0 \$56__t0 \$56 52.6733
* device instance _56_t1 r0 *1 0,0
R_56_t1 \$56__t1 \$56 52.6733
* device instance _56 r0 *1 0,0
C_56 \$56 vsubs 1.327841e-15
* device instance _57_t0 r0 *1 0,0
R_57_t0 \$57__t0 \$57 52.6733
* device instance _57_t1 r0 *1 0,0
R_57_t1 \$57__t1 \$57 52.6733
* device instance _57 r0 *1 0,0
C_57 \$57 vsubs 1.327841e-15
* device instance _58_t0 r0 *1 0,0
R_58_t0 \$58__t0 \$58 52.6733
* device instance _58_t1 r0 *1 0,0
R_58_t1 \$58__t1 \$58 52.6733
* device instance _58 r0 *1 0,0
C_58 \$58 vsubs 1.327841e-15
* device instance _59_t0 r0 *1 0,0
R_59_t0 \$59__t0 \$59 52.6733
* device instance _59_t1 r0 *1 0,0
R_59_t1 \$59__t1 \$59 52.6733
* device instance _59 r0 *1 0,0
C_59 \$59 vsubs 1.327841e-15
* device instance _60_t0 r0 *1 0,0
R_60_t0 \$60__t0 \$60 52.6733
* device instance _60_t1 r0 *1 0,0
R_60_t1 \$60__t1 \$60 52.6733
* device instance _60 r0 *1 0,0
C_60 \$60 vsubs 1.327841e-15
* device instance _61_t0 r0 *1 0,0
R_61_t0 \$61__t0 \$61 52.6733
* device instance _61_t1 r0 *1 0,0
R_61_t1 \$61__t1 \$61 52.6733
* device instance _61 r0 *1 0,0
C_61 \$61 vsubs 1.327841e-15
* device instance _62_t0 r0 *1 0,0
R_62_t0 \$62__t0 \$62 52.6733
* device instance _62_t1 r0 *1 0,0
R_62_t1 \$62__t1 \$62 52.6733
* device instance _62 r0 *1 0,0
C_62 \$62 vsubs 1.327841e-15
* device instance _63_t0 r0 *1 0,0
R_63_t0 \$63__t0 \$63 52.6733
* device instance _63_t1 r0 *1 0,0
R_63_t1 \$63__t1 \$63 52.6733
* device instance _63 r0 *1 0,0
C_63 \$63 vsubs 1.327841e-15
* device instance _64_t0 r0 *1 0,0
R_64_t0 \$64__t0 \$64 53.46165
* device instance _64_t1 r0 *1 0,0
R_64_t1 \$64__t1 \$64 53.46165
* device instance _64 r0 *1 0,0
C_64 \$64 vsubs 1.584077e-15
* device instance _65_t0 r0 *1 0,0
R_65_t0 \$65__t0 \$65 53.0572
* device instance _65_t1 r0 *1 0,0
R_65_t1 \$65__t1 \$65 53.0572
* device instance _65 r0 *1 0,0
C_65 \$65 vsubs 1.443703e-15
* device instance _66_t0 r0 *1 0,0
R_66_t0 \$66__t0 \$66 60.06445
* device instance _66_t1 r0 *1 0,0
R_66_t1 \$66__t1 \$66 60.06445
* device instance _66 r0 *1 0,0
C_66 \$66 vsubs 3.794735e-15
* device instance _67_t0 r0 *1 0,0
R_67_t0 \$67__t0 \$67 52.84925
* device instance _67_t1 r0 *1 0,0
R_67_t1 \$67__t1 \$67 52.84925
* device instance _67 r0 *1 0,0
C_67 \$67 vsubs 1.371243e-15
* device instance _68_t0 r0 *1 0,0
R_68_t0 \$68__t0 \$68 52.6733
* device instance _68_t1 r0 *1 0,0
R_68_t1 \$68__t1 \$68 52.6733
* device instance _68 r0 *1 0,0
C_68 \$68 vsubs 1.327841e-15
* device instance _69_t0 r0 *1 0,0
R_69_t0 \$69__t0 \$69 52.6733
* device instance _69_t1 r0 *1 0,0
R_69_t1 \$69__t1 \$69 52.6733
* device instance _69 r0 *1 0,0
C_69 \$69 vsubs 1.327841e-15
* device instance _7_t0 r0 *1 0,0
R_7_t0 \$7__t0 \$7 52.6733
* device instance _7_t1 r0 *1 0,0
R_7_t1 \$7__t1 \$7 52.6733
* device instance _7 r0 *1 0,0
C_7 \$7 vsubs 1.327841e-15
* device instance _70_t0 r0 *1 0,0
R_70_t0 \$70__t0 \$70 52.6733
* device instance _70_t1 r0 *1 0,0
R_70_t1 \$70__t1 \$70 52.6733
* device instance _70 r0 *1 0,0
C_70 \$70 vsubs 1.327841e-15
* device instance _71_t0 r0 *1 0,0
R_71_t0 \$71__t0 \$71 52.6733
* device instance _71_t1 r0 *1 0,0
R_71_t1 \$71__t1 \$71 52.6733
* device instance _71 r0 *1 0,0
C_71 \$71 vsubs 1.327841e-15
* device instance _72_t0 r0 *1 0,0
R_72_t0 \$72__t0 \$72 52.6733
* device instance _72_t1 r0 *1 0,0
R_72_t1 \$72__t1 \$72 52.6733
* device instance _72 r0 *1 0,0
C_72 \$72 vsubs 1.327841e-15
* device instance _73_t0 r0 *1 0,0
R_73_t0 \$73__t0 \$73 52.6733
* device instance _73_t1 r0 *1 0,0
R_73_t1 \$73__t1 \$73 52.6733
* device instance _73 r0 *1 0,0
C_73 \$73 vsubs 1.327841e-15
* device instance _74_t0 r0 *1 0,0
R_74_t0 \$74__t0 \$74 52.6733
* device instance _74_t1 r0 *1 0,0
R_74_t1 \$74__t1 \$74 52.6733
* device instance _74 r0 *1 0,0
C_74 \$74 vsubs 1.327841e-15
* device instance _75_t0 r0 *1 0,0
R_75_t0 \$75__t0 \$75 52.6733
* device instance _75_t1 r0 *1 0,0
R_75_t1 \$75__t1 \$75 52.6733
* device instance _75 r0 *1 0,0
C_75 \$75 vsubs 1.33157e-15
* device instance _78_t0 r0 *1 0,0
R_78_t0 \$78__t0 \$78 52.6733
* device instance _78_t1 r0 *1 0,0
R_78_t1 \$78__t1 \$78 52.6733
* device instance _78 r0 *1 0,0
C_78 \$78 vsubs 1.327841e-15
* device instance _79_t0 r0 *1 0,0
R_79_t0 \$79__t0 \$79 52.6733
* device instance _79_t1 r0 *1 0,0
R_79_t1 \$79__t1 \$79 52.6733
* device instance _79 r0 *1 0,0
C_79 \$79 vsubs 1.327841e-15
* device instance _8_t0 r0 *1 0,0
R_8_t0 \$8__t0 \$8 52.6733
* device instance _8_t1 r0 *1 0,0
R_8_t1 \$8__t1 \$8 52.6733
* device instance _8 r0 *1 0,0
C_8 \$8 vsubs 1.327841e-15
* device instance _80_t0 r0 *1 0,0
R_80_t0 \$80__t0 \$80 52.6733
* device instance _80_t1 r0 *1 0,0
R_80_t1 \$80__t1 \$80 52.6733
* device instance _80 r0 *1 0,0
C_80 \$80 vsubs 1.327841e-15
* device instance _81_t0 r0 *1 0,0
R_81_t0 \$81__t0 \$81 52.6733
* device instance _81_t1 r0 *1 0,0
R_81_t1 \$81__t1 \$81 52.6733
* device instance _81 r0 *1 0,0
C_81 \$81 vsubs 1.327841e-15
* device instance _82_t0 r0 *1 0,0
R_82_t0 \$82__t0 \$82 52.6733
* device instance _82_t1 r0 *1 0,0
R_82_t1 \$82__t1 \$82 52.6733
* device instance _82 r0 *1 0,0
C_82 \$82 vsubs 1.327841e-15
* device instance _83_t0 r0 *1 0,0
R_83_t0 \$83__t0 \$83 52.6733
* device instance _83_t1 r0 *1 0,0
R_83_t1 \$83__t1 \$83 52.6733
* device instance _83 r0 *1 0,0
C_83 \$83 vsubs 1.327841e-15
* device instance _84_t0 r0 *1 0,0
R_84_t0 \$84__t0 \$84 52.6733
* device instance _84_t1 r0 *1 0,0
R_84_t1 \$84__t1 \$84 52.6733
* device instance _84 r0 *1 0,0
C_84 \$84 vsubs 1.327841e-15
* device instance _85_t0 r0 *1 0,0
R_85_t0 \$85__t0 \$85 52.6733
* device instance _85_t1 r0 *1 0,0
R_85_t1 \$85__t1 \$85 52.6733
* device instance _85 r0 *1 0,0
C_85 \$85 vsubs 1.327841e-15
* device instance _86_t0 r0 *1 0,0
R_86_t0 \$86__t0 \$86 53.46165
* device instance _86_t1 r0 *1 0,0
R_86_t1 \$86__t1 \$86 53.46165
* device instance _86 r0 *1 0,0
C_86 \$86 vsubs 1.584077e-15
* device instance _89_t0 r0 *1 0,0
R_89_t0 \$89__t0 \$89 51.50145
* device instance _89_t1 r0 *1 0,0
R_89_t1 \$89__t1 \$89 51.50145
* device instance _89 r0 *1 0,0
C_89 \$89 vsubs 9.34868e-16
* device instance _9_t0 r0 *1 0,0
R_9_t0 \$9__t0 \$9 52.6733
* device instance _9_t1 r0 *1 0,0
R_9_t1 \$9__t1 \$9 52.6733
* device instance _9 r0 *1 0,0
C_9 \$9 vsubs 1.327841e-15
* device instance _90_t0 r0 *1 0,0
R_90_t0 \$90__t0 \$90 51.50145
* device instance _90_t1 r0 *1 0,0
R_90_t1 \$90__t1 \$90 51.50145
* device instance _90 r0 *1 0,0
C_90 \$90 vsubs 9.34868e-16
* device instance _91_t0 r0 *1 0,0
R_91_t0 \$91__t0 \$91 51.50145
* device instance _91_t1 r0 *1 0,0
R_91_t1 \$91__t1 \$91 51.50145
* device instance _91 r0 *1 0,0
C_91 \$91 vsubs 9.34868e-16
* device instance _92_t0 r0 *1 0,0
R_92_t0 \$92__t0 \$92 51.50145
* device instance _92_t1 r0 *1 0,0
R_92_t1 \$92__t1 \$92 51.50145
* device instance _92 r0 *1 0,0
C_92 \$92 vsubs 9.34868e-16
* device instance _93_t0 r0 *1 0,0
R_93_t0 \$93__t0 \$93 51.50145
* device instance _93_t1 r0 *1 0,0
R_93_t1 \$93__t1 \$93 51.50145
* device instance _93 r0 *1 0,0
C_93 \$93 vsubs 9.34868e-16
* device instance _94_t0 r0 *1 0,0
R_94_t0 \$94__t0 \$94 51.50145
* device instance _94_t1 r0 *1 0,0
R_94_t1 \$94__t1 \$94 51.50145
* device instance _94 r0 *1 0,0
C_94 \$94 vsubs 9.34868e-16
* device instance _95_t0 r0 *1 0,0
R_95_t0 \$95__t0 \$95 51.50145
* device instance _95_t1 r0 *1 0,0
R_95_t1 \$95__t1 \$95 51.50145
* device instance _95 r0 *1 0,0
C_95 \$95 vsubs 9.34868e-16
* device instance _96_t0 r0 *1 0,0
R_96_t0 \$96__t0 \$96 51.50145
* device instance _96_t1 r0 *1 0,0
R_96_t1 \$96__t1 \$96 51.50145
* device instance _96 r0 *1 0,0
C_96 \$96 vsubs 9.34868e-16
* device instance _97_t0 r0 *1 0,0
R_97_t0 \$97__t0 \$97 52.29125
* device instance _97_t1 r0 *1 0,0
R_97_t1 \$97__t1 \$97 52.29125
* device instance _97 r0 *1 0,0
C_97 \$97 vsubs 1.191104e-15
* device instance _98_t0 r0 *1 0,0
R_98_t0 \$98__t0 \$98 60.06445
* device instance _98_t1 r0 *1 0,0
R_98_t1 \$98__t1 \$98 60.06445
* device instance _98 r0 *1 0,0
C_98 \$98 vsubs 3.794735e-15
* device instance _99_t0 r0 *1 0,0
R_99_t0 \$99__t0 \$99 53.0572
* device instance _99_t1 r0 *1 0,0
R_99_t1 \$99__t1 \$99 53.0572
* device instance _99 r0 *1 0,0
C_99 \$99 vsubs 1.443703e-15
* device instance D1_t0 r0 *1 0,0
RD1_t0 D1__t0 D1 729.838814737
* device instance D1_t1 r0 *1 0,0
RD1_t1 D1__t1 D1 402.833314494
* device instance D1_t2 r0 *1 0,0
RD1_t2 D1__t2 D1 623.883559465
* device instance D1_t3 r0 *1 0,0
RD1_t3 D1__t3 D1 348.435986289
* device instance D1_t4 r0 *1 0,0
RD1_t4 D1__t4 D1 187.297473217
* device instance D1_t5 r0 *1 0,0
RD1_t5 D1__t5 D1 110.97870328
* device instance D1_t6 r0 *1 0,0
RD1_t6 D1__t6 D1 483.6663099
* device instance D1_t7 r0 *1 0,0
RD1_t7 D1__t7 D1 464.701288026
* device instance D1_t8 r0 *1 0,0
RD1_t8 D1__t8 D1 348.435986289
* device instance D1_t9 r0 *1 0,0
RD1_t9 D1__t9 D1 187.297473217
* device instance D1_t10 r0 *1 0,0
RD1_t10 D1__t10 D1 110.97870328
* device instance D1_t11 r0 *1 0,0
RD1_t11 D1__t11 D1 483.6663099
* device instance D1_t12 r0 *1 0,0
RD1_t12 D1__t12 D1 393.944833241
* device instance D1_t13 r0 *1 0,0
RD1_t13 D1__t13 D1 544.087501044
* device instance D1_t14 r0 *1 0,0
RD1_t14 D1__t14 D1 697.956914715
* device instance D1_t15 r0 *1 0,0
RD1_t15 D1__t15 D1 761.250583905
* device instance D1_t16 r0 *1 0,0
RD1_t16 D1__t16 D1 602.704588552
* device instance D1_t17 r0 *1 0,0
RD1_t17 D1__t17 D1 444.158934934
* device instance D1_t18 r0 *1 0,0
RD1_t18 D1__t18 D1 285.614192142
* device instance D1_t19 r0 *1 0,0
RD1_t19 D1__t19 D1 254.220029374
* device instance D1 r0 *1 0,0
CD1 D1 vsubs 7.9307937e-14
* device instance D2_t0 r0 *1 0,0
RD2_t0 D2__t0 D2 787.667302602
* device instance D2_t1 r0 *1 0,0
RD2_t1 D2__t1 D2 55.3923863728
* device instance D2_t2 r0 *1 0,0
RD2_t2 D2__t2 D2 55.3923863728
* device instance D2_t3 r0 *1 0,0
RD2_t3 D2__t3 D2 358.925120408
* device instance D2_t4 r0 *1 0,0
RD2_t4 D2__t4 D2 602.412994291
* device instance D2_t5 r0 *1 0,0
RD2_t5 D2__t5 D2 511.133178119
* device instance D2_t6 r0 *1 0,0
RD2_t6 D2__t6 D2 766.751544804
* device instance D2_t7 r0 *1 0,0
RD2_t7 D2__t7 D2 214.043986065
* device instance D2_t8 r0 *1 0,0
RD2_t8 D2__t8 D2 500.903505281
* device instance D2_t9 r0 *1 0,0
RD2_t9 D2__t9 D2 339.972319527
* device instance D2_t10 r0 *1 0,0
RD2_t10 D2__t10 D2 214.043986065
* device instance D2_t11 r0 *1 0,0
RD2_t11 D2__t11 D2 500.903505281
* device instance D2_t12 r0 *1 0,0
RD2_t12 D2__t12 D2 339.972319527
* device instance D2_t13 r0 *1 0,0
RD2_t13 D2__t13 D2 209.5536634
* device instance D2_t14 r0 *1 0,0
RD2_t14 D2__t14 D2 326.918970649
* device instance D2_t15 r0 *1 0,0
RD2_t15 D2__t15 D2 475.611740189
* device instance D2_t16 r0 *1 0,0
RD2_t16 D2__t16 D2 630.387010345
* device instance D2_t17 r0 *1 0,0
RD2_t17 D2__t17 D2 531.576679244
* device instance D2_t18 r0 *1 0,0
RD2_t18 D2__t18 D2 370.56427404
* device instance D2_t19 r0 *1 0,0
RD2_t19 D2__t19 D2 692.589627418
* device instance D2 r0 *1 0,0
CD2 D2 vsubs 8.292151e-14
* device instance GDRV_t0 r0 *1 0,0
RGDRV_t0 GDRV__t0 GDRV 848.634975765
* device instance GDRV_t1 r0 *1 0,0
RGDRV_t1 GDRV__t1 GDRV 893.966007606
* device instance GDRV_t2 r0 *1 0,0
RGDRV_t2 GDRV__t2 GDRV 959.249289814
* device instance GDRV_t3 r0 *1 0,0
RGDRV_t3 GDRV__t3 GDRV 185.811716116
* device instance GDRV_t4 r0 *1 0,0
RGDRV_t4 GDRV__t4 GDRV 535.65613317
* device instance GDRV_t5 r0 *1 0,0
RGDRV_t5 GDRV__t5 GDRV 383.690214591
* device instance GDRV_t6 r0 *1 0,0
RGDRV_t6 GDRV__t6 GDRV 680.179931504
* device instance GDRV_t7 r0 *1 0,0
RGDRV_t7 GDRV__t7 GDRV 185.275561826
* device instance GDRV_t8 r0 *1 0,0
RGDRV_t8 GDRV__t8 GDRV 296.339344295
* device instance GDRV_t9 r0 *1 0,0
RGDRV_t9 GDRV__t9 GDRV 322.633835238
* device instance GDRV_t10 r0 *1 0,0
RGDRV_t10 GDRV__t10 GDRV 420.753232036
* device instance GDRV_t11 r0 *1 0,0
RGDRV_t11 GDRV__t11 GDRV 741.737128702
* device instance GDRV_t12 r0 *1 0,0
RGDRV_t12 GDRV__t12 GDRV 624.103427772
* device instance GDRV_t13 r0 *1 0,0
RGDRV_t13 GDRV__t13 GDRV 514.356404784
* device instance GDRV_t14 r0 *1 0,0
RGDRV_t14 GDRV__t14 GDRV 418.743639775
* device instance GDRV_t15 r0 *1 0,0
RGDRV_t15 GDRV__t15 GDRV 128.698728689
* device instance GDRV_t16 r0 *1 0,0
RGDRV_t16 GDRV__t16 GDRV 349.079163922
* device instance GDRV_t17 r0 *1 0,0
RGDRV_t17 GDRV__t17 GDRV 349.364026082
* device instance GDRV_t18 r0 *1 0,0
RGDRV_t18 GDRV__t18 GDRV 549.52330222
* device instance GDRV_t19 r0 *1 0,0
RGDRV_t19 GDRV__t19 GDRV 811.812737571
* device instance GDRV_t20 r0 *1 0,0
RGDRV_t20 GDRV__t20 GDRV 864.042330999
* device instance GDRV_t21 r0 *1 0,0
RGDRV_t21 GDRV__t21 GDRV 772.075089768
* device instance GDRV_t22 r0 *1 0,0
RGDRV_t22 GDRV__t22 GDRV 373.813834615
* device instance GDRV_t23 r0 *1 0,0
RGDRV_t23 GDRV__t23 GDRV 628.895094825
* device instance GDRV_t24 r0 *1 0,0
RGDRV_t24 GDRV__t24 GDRV 518.531660217
* device instance GDRV_t25 r0 *1 0,0
RGDRV_t25 GDRV__t25 GDRV 861.905072352
* device instance GDRV_t26 r0 *1 0,0
RGDRV_t26 GDRV__t26 GDRV 845.038252939
* device instance GDRV_t27 r0 *1 0,0
RGDRV_t27 GDRV__t27 GDRV 877.715510822
* device instance GDRV_t28 r0 *1 0,0
RGDRV_t28 GDRV__t28 GDRV 255.643212889
* device instance GDRV_t29 r0 *1 0,0
RGDRV_t29 GDRV__t29 GDRV 336.216889021
* device instance GDRV_t30 r0 *1 0,0
RGDRV_t30 GDRV__t30 GDRV 475.413511184
* device instance GDRV_t31 r0 *1 0,0
RGDRV_t31 GDRV__t31 GDRV 587.502302149
* device instance GDRV_t32 r0 *1 0,0
RGDRV_t32 GDRV__t32 GDRV 727.727812737
* device instance GDRV_t33 r0 *1 0,0
RGDRV_t33 GDRV__t33 GDRV 218.1607354
* device instance GDRV_t34 r0 *1 0,0
RGDRV_t34 GDRV__t34 GDRV 154.369188604
* device instance GDRV r0 *1 0,0
CGDRV GDRV vsubs 1.58064518e-13
* device instance NE_t0 r0 *1 0,0
RNE_t0 NE__t0 NE 766.491771077
* device instance NE_t1 r0 *1 0,0
RNE_t1 NE__t1 NE 88.670216196
* device instance NE_t2 r0 *1 0,0
RNE_t2 NE__t2 NE 95.6068048138
* device instance NE_t3 r0 *1 0,0
RNE_t3 NE__t3 NE 119.588276054
* device instance NE_t4 r0 *1 0,0
RNE_t4 NE__t4 NE 152.78904139
* device instance NE_t5 r0 *1 0,0
RNE_t5 NE__t5 NE 63.7517309786
* device instance NE_t6 r0 *1 0,0
RNE_t6 NE__t6 NE 73.0926609806
* device instance NE_t7 r0 *1 0,0
RNE_t7 NE__t7 NE 102.485275684
* device instance NE_t8 r0 *1 0,0
RNE_t8 NE__t8 NE 139.808322826
* device instance NE r0 *1 0,0
CNE NE vsubs 1.1912622e-14
* device instance NG_t0 r0 *1 0,0
RNG_t0 NG__t0 NG 866.064083394
* device instance NG_t1 r0 *1 0,0
RNG_t1 NG__t1 NG 126.020122757
* device instance NG_t2 r0 *1 0,0
RNG_t2 NG__t2 NG 126.020122757
* device instance NG_t3 r0 *1 0,0
RNG_t3 NG__t3 NG 614.784071092
* device instance NG r0 *1 0,0
CNG NG vsubs 1.5032441e-14
* device instance PN_t0 r0 *1 0,0
RPN_t0 PN__t0 PN 386.959837049
* device instance PN_t1 r0 *1 0,0
RPN_t1 PN__t1 PN 376.532533125
* device instance PN_t2 r0 *1 0,0
RPN_t2 PN__t2 PN 549.2123613
* device instance PN_t3 r0 *1 0,0
RPN_t3 PN__t3 PN 462.859893743
* device instance PN_t4 r0 *1 0,0
RPN_t4 PN__t4 PN 635.579702483
* device instance PN_t5 r0 *1 0,0
RPN_t5 PN__t5 PN 128.242053145
* device instance PN_t6 r0 *1 0,0
RPN_t6 PN__t6 PN 47.4002374113
* device instance PN_t7 r0 *1 0,0
RPN_t7 PN__t7 PN 47.4002374113
* device instance PN_t8 r0 *1 0,0
RPN_t8 PN__t8 PN 43.3612895706
* device instance PN_t9 r0 *1 0,0
RPN_t9 PN__t9 PN 128.242053145
* device instance PN_t10 r0 *1 0,0
RPN_t10 PN__t10 PN 214.346100481
* device instance PN_t11 r0 *1 0,0
RPN_t11 PN__t11 PN 214.346100481
* device instance PN_t12 r0 *1 0,0
RPN_t12 PN__t12 PN 300.62415276
* device instance PN_t13 r0 *1 0,0
RPN_t13 PN__t13 PN 386.959837049
* device instance PN_t14 r0 *1 0,0
RPN_t14 PN__t14 PN 300.62415276
* device instance PN_t15 r0 *1 0,0
RPN_t15 PN__t15 PN 218.579862198
* device instance PN_t16 r0 *1 0,0
RPN_t16 PN__t16 PN 218.579862198
* device instance PN_t17 r0 *1 0,0
RPN_t17 PN__t17 PN 132.460437169
* device instance PN_t18 r0 *1 0,0
RPN_t18 PN__t18 PN 132.460437169
* device instance PN_t19 r0 *1 0,0
RPN_t19 PN__t19 PN 43.3612895706
* device instance PN_t20 r0 *1 0,0
RPN_t20 PN__t20 PN 128.242053145
* device instance PN_t21 r0 *1 0,0
RPN_t21 PN__t21 PN 47.4002374113
* device instance PN_t22 r0 *1 0,0
RPN_t22 PN__t22 PN 214.346100481
* device instance PN_t23 r0 *1 0,0
RPN_t23 PN__t23 PN 386.959837049
* device instance PN_t24 r0 *1 0,0
RPN_t24 PN__t24 PN 300.62415276
* device instance PN_t25 r0 *1 0,0
RPN_t25 PN__t25 PN 218.579862198
* device instance PN_t26 r0 *1 0,0
RPN_t26 PN__t26 PN 132.460437169
* device instance PN_t27 r0 *1 0,0
RPN_t27 PN__t27 PN 43.3612895706
* device instance PN r0 *1 0,0
CPN PN vsubs 6.3322936e-14
* device instance TAIL_t0 r0 *1 0,0
RTAIL_t0 TAIL__t0 TAIL 652.283118742
* device instance TAIL_t1 r0 *1 0,0
RTAIL_t1 TAIL__t1 TAIL 926.468556756
* device instance TAIL_t2 r0 *1 0,0
RTAIL_t2 TAIL__t2 TAIL 652.283118742
* device instance TAIL_t3 r0 *1 0,0
RTAIL_t3 TAIL__t3 TAIL 715.472650625
* device instance TAIL_t4 r0 *1 0,0
RTAIL_t4 TAIL__t4 TAIL 510.221821501
* device instance TAIL_t5 r0 *1 0,0
RTAIL_t5 TAIL__t5 TAIL 321.899932726
* device instance TAIL_t6 r0 *1 0,0
RTAIL_t6 TAIL__t6 TAIL 204.403748624
* device instance TAIL_t7 r0 *1 0,0
RTAIL_t7 TAIL__t7 TAIL 273.514687766
* device instance TAIL_t8 r0 *1 0,0
RTAIL_t8 TAIL__t8 TAIL 450.230765947
* device instance TAIL_t9 r0 *1 0,0
RTAIL_t9 TAIL__t9 TAIL 273.514687766
* device instance TAIL_t10 r0 *1 0,0
RTAIL_t10 TAIL__t10 TAIL 204.403748624
* device instance TAIL_t11 r0 *1 0,0
RTAIL_t11 TAIL__t11 TAIL 321.899932726
* device instance TAIL_t12 r0 *1 0,0
RTAIL_t12 TAIL__t12 TAIL 510.221821501
* device instance TAIL_t13 r0 *1 0,0
RTAIL_t13 TAIL__t13 TAIL 715.472650625
* device instance TAIL_t14 r0 *1 0,0
RTAIL_t14 TAIL__t14 TAIL 450.230765947
* device instance TAIL_t15 r0 *1 0,0
RTAIL_t15 TAIL__t15 TAIL 926.468556756
* device instance TAIL_t16 r0 *1 0,0
RTAIL_t16 TAIL__t16 TAIL 1170.24425217
* device instance TAIL_t17 r0 *1 0,0
RTAIL_t17 TAIL__t17 TAIL 1107.64098246
* device instance TAIL r0 *1 0,0
CTAIL TAIL vsubs 5.744609e-14
* device instance VA_t0 r0 *1 0,0
RVA_t0 VA__t0 VA 325.943589065
* device instance VA_t1 r0 *1 0,0
RVA_t1 VA__t1 VA 100.14287973
* device instance VA_t2 r0 *1 0,0
RVA_t2 VA__t2 VA 490.57279595
* device instance VA_t3 r0 *1 0,0
RVA_t3 VA__t3 VA 392.718220827
* device instance VA_t4 r0 *1 0,0
RVA_t4 VA__t4 VA 275.239928057
* device instance VA_t5 r0 *1 0,0
RVA_t5 VA__t5 VA 166.405177586
* device instance VA_t6 r0 *1 0,0
RVA_t6 VA__t6 VA 289.344953613
* device instance VA_t7 r0 *1 0,0
RVA_t7 VA__t7 VA 383.391394142
* device instance VA_t8 r0 *1 0,0
RVA_t8 VA__t8 VA 225.513395086
* device instance VA_t9 r0 *1 0,0
RVA_t9 VA__t9 VA 396.645559907
* device instance VA_t10 r0 *1 0,0
RVA_t10 VA__t10 VA 304.730935115
* device instance VA_t11 r0 *1 0,0
RVA_t11 VA__t11 VA 313.967481336
* device instance VA_t12 r0 *1 0,0
RVA_t12 VA__t12 VA 323.276059078
* device instance VA_t13 r0 *1 0,0
RVA_t13 VA__t13 VA 298.488381166
* device instance VA_t14 r0 *1 0,0
RVA_t14 VA__t14 VA 307.559353126
* device instance VA_t15 r0 *1 0,0
RVA_t15 VA__t15 VA 316.713422854
* device instance VA_t16 r0 *1 0,0
RVA_t16 VA__t16 VA 295.573173363
* device instance VA r0 *1 0,0
CVA VA vsubs 4.5547684e-14
* device instance VB_n0 r0 *1 0,0
CVB_n0 VB__t3 vsubs 1.77035256636e-15
* device instance VB_n1 r0 *1 0,0
CVB_n1 VB__t2 vsubs 3.54070513271e-15
* device instance VB_n2 r0 *1 0,0
CVB_n2 VB__t4 vsubs 3.54070513271e-15
* device instance VB_n3 r0 *1 0,0
CVB_n3 VB__t1 vsubs 3.54070513271e-15
* device instance VB_n4 r0 *1 0,0
CVB_n4 VB__t5 vsubs 3.54070513271e-15
* device instance VB_n5 r0 *1 0,0
CVB_n5 VB vsubs 3.54070513271e-15
* device instance VB_n6 r0 *1 0,0
CVB_n6 VB__t6 vsubs 3.54070513271e-15
* device instance VB_n7 r0 *1 0,0
CVB_n7 VB__t7 vsubs 4.42987865393e-15
* device instance VB_n8 r0 *1 0,0
CVB_n8 VB__t8 vsubs 6.31316953551e-15
* device instance VB_n9 r0 *1 0,0
CVB_n9 VB__t9 vsubs 3.65364344794e-15
* device instance VB_seg0 r0 *1 0,0
RVB_seg0 VB__t3 VB__t2 484.053612298
* device instance VB_seg1 r0 *1 0,0
RVB_seg1 VB__t2 VB__t4 484.053612298
* device instance VB_seg2 r0 *1 0,0
RVB_seg2 VB__t4 VB__t1 484.053612298
* device instance VB_seg3 r0 *1 0,0
RVB_seg3 VB__t1 VB__t5 484.053612298
* device instance VB_seg4 r0 *1 0,0
RVB_seg4 VB__t5 VB 484.053612298
* device instance VB_seg5 r0 *1 0,0
RVB_seg5 VB VB__t6 484.053612298
* device instance VB_seg6 r0 *1 0,0
RVB_seg6 VB__t6 VB__t7 484.053612298
* device instance VB_seg7 r0 *1 0,0
RVB_seg7 VB__t7 VB__t8 727.173351883
* device instance VB_seg8 r0 *1 0,0
RVB_seg8 VB__t8 VB__t9 998.987062031
* device instance VBQ_n0 r0 *1 0,0
CVBQ_n0 VBQ__t4 vsubs 4.15420755326e-16
* device instance VBQ_n1 r0 *1 0,0
CVBQ_n1 VBQ__t1 vsubs 1.06938117566e-15
* device instance VBQ_n2 r0 *1 0,0
CVBQ_n2 VBQ__t5 vsubs 1.06938117566e-15
* device instance VBQ_n3 r0 *1 0,0
CVBQ_n3 VBQ__t7 vsubs 1.06938117566e-15
* device instance VBQ_n4 r0 *1 0,0
CVBQ_n4 VBQ vsubs 1.06938117566e-15
* device instance VBQ_n5 r0 *1 0,0
CVBQ_n5 VBQ__t2 vsubs 1.06938117566e-15
* device instance VBQ_n6 r0 *1 0,0
CVBQ_n6 VBQ__t0 vsubs 1.06938117566e-15
* device instance VBQ_n7 r0 *1 0,0
CVBQ_n7 VBQ__t3 vsubs 4.72826397302e-15
* device instance VBQ_n8 r0 *1 0,0
CVBQ_n8 VBQ__t8 vsubs 4.31284321769e-15
* device instance VBQ_seg0 r0 *1 0,0
RVBQ_seg0 VBQ__t4 VBQ__t1 10.4436995351
* device instance VBQ_seg1 r0 *1 0,0
RVBQ_seg1 VBQ__t1 VBQ__t5 16.4405992003
* device instance VBQ_seg2 r0 *1 0,0
RVBQ_seg2 VBQ__t5 VBQ__t7 10.4436995351
* device instance VBQ_seg3 r0 *1 0,0
RVBQ_seg3 VBQ__t7 VBQ 16.4405992003
* device instance VBQ_seg4 r0 *1 0,0
RVBQ_seg4 VBQ VBQ__t2 10.4436995351
* device instance VBQ_seg5 r0 *1 0,0
RVBQ_seg5 VBQ__t2 VBQ__t0 16.4405992003
* device instance VBQ_seg6 r0 *1 0,0
RVBQ_seg6 VBQ__t0 VBQ__t3 10.4436995351
* device instance VBQ_seg7 r0 *1 0,0
RVBQ_seg7 VBQ__t3 VBQ__t8 108.425104259
* device instance VDD_t0 r0 *1 0,0
RVDD_t0 VDD__t0 VDD 998.171556531
* device instance VDD_t1 r0 *1 0,0
RVDD_t1 VDD__t1 VDD 998.171556531
* device instance VDD_t2 r0 *1 0,0
RVDD_t2 VDD__t2 VDD 1032.20903775
* device instance VDD_t3 r0 *1 0,0
RVDD_t3 VDD__t3 VDD 1032.20903775
* device instance VDD_t4 r0 *1 0,0
RVDD_t4 VDD__t4 VDD 777.081045622
* device instance VDD_t5 r0 *1 0,0
RVDD_t5 VDD__t5 VDD 1149.52286262
* device instance VDD_t6 r0 *1 0,0
RVDD_t6 VDD__t6 VDD 254.998021101
* device instance VDD_t7 r0 *1 0,0
RVDD_t7 VDD__t7 VDD 254.998021101
* device instance VDD_t8 r0 *1 0,0
RVDD_t8 VDD__t8 VDD 254.998021101
* device instance VDD_t9 r0 *1 0,0
RVDD_t9 VDD__t9 VDD 653.734823348
* device instance VDD_t10 r0 *1 0,0
RVDD_t10 VDD__t10 VDD 645.338737243
* device instance VDD_t11 r0 *1 0,0
RVDD_t11 VDD__t11 VDD 989.859121333
* device instance VDD_t12 r0 *1 0,0
RVDD_t12 VDD__t12 VDD 362.302477027
* device instance VDD_t13 r0 *1 0,0
RVDD_t13 VDD__t13 VDD 503.87757222
* device instance VDD_t14 r0 *1 0,0
RVDD_t14 VDD__t14 VDD 502.999996573
* device instance VDD_t15 r0 *1 0,0
RVDD_t15 VDD__t15 VDD 660.450942892
* device instance VDD_t16 r0 *1 0,0
RVDD_t16 VDD__t16 VDD 1079.13076013
* device instance VDD_t17 r0 *1 0,0
RVDD_t17 VDD__t17 VDD 928.909964833
* device instance VDD_t18 r0 *1 0,0
RVDD_t18 VDD__t18 VDD 787.970535828
* device instance VDD_t19 r0 *1 0,0
RVDD_t19 VDD__t19 VDD 662.264845174
* device instance VDD_t20 r0 *1 0,0
RVDD_t20 VDD__t20 VDD 261.355847813
* device instance VDD_t21 r0 *1 0,0
RVDD_t21 VDD__t21 VDD 562.107820819
* device instance VDD_t22 r0 *1 0,0
RVDD_t22 VDD__t22 VDD 499.726033074
* device instance VDD_t23 r0 *1 0,0
RVDD_t23 VDD__t23 VDD 823.511751829
* device instance VDD_t24 r0 *1 0,0
RVDD_t24 VDD__t24 VDD 1158.07766235
* device instance VDD_t25 r0 *1 0,0
RVDD_t25 VDD__t25 VDD 1235.25138712
* device instance VDD_t26 r0 *1 0,0
RVDD_t26 VDD__t26 VDD 989.859121333
* device instance VDD_t27 r0 *1 0,0
RVDD_t27 VDD__t27 VDD 362.302477027
* device instance VDD_t28 r0 *1 0,0
RVDD_t28 VDD__t28 VDD 503.87757222
* device instance VDD_t29 r0 *1 0,0
RVDD_t29 VDD__t29 VDD 502.999996573
* device instance VDD_t30 r0 *1 0,0
RVDD_t30 VDD__t30 VDD 660.450942892
* device instance VDD_t31 r0 *1 0,0
RVDD_t31 VDD__t31 VDD 1079.13076013
* device instance VDD_t32 r0 *1 0,0
RVDD_t32 VDD__t32 VDD 928.909964833
* device instance VDD_t33 r0 *1 0,0
RVDD_t33 VDD__t33 VDD 787.970535828
* device instance VDD_t34 r0 *1 0,0
RVDD_t34 VDD__t34 VDD 662.264845174
* device instance VDD_t35 r0 *1 0,0
RVDD_t35 VDD__t35 VDD 261.355847813
* device instance VDD_t36 r0 *1 0,0
RVDD_t36 VDD__t36 VDD 562.107820819
* device instance VDD_t37 r0 *1 0,0
RVDD_t37 VDD__t37 VDD 499.726033074
* device instance VDD_t38 r0 *1 0,0
RVDD_t38 VDD__t38 VDD 823.511751829
* device instance VDD_t39 r0 *1 0,0
RVDD_t39 VDD__t39 VDD 1158.07766235
* device instance VDD_t40 r0 *1 0,0
RVDD_t40 VDD__t40 VDD 1235.25138712
* device instance VDD_t41 r0 *1 0,0
RVDD_t41 VDD__t41 VDD 989.859121333
* device instance VDD_t42 r0 *1 0,0
RVDD_t42 VDD__t42 VDD 362.302477027
* device instance VDD_t43 r0 *1 0,0
RVDD_t43 VDD__t43 VDD 503.87757222
* device instance VDD_t44 r0 *1 0,0
RVDD_t44 VDD__t44 VDD 502.999996573
* device instance VDD_t45 r0 *1 0,0
RVDD_t45 VDD__t45 VDD 660.450942892
* device instance VDD_t46 r0 *1 0,0
RVDD_t46 VDD__t46 VDD 1079.13076013
* device instance VDD_t47 r0 *1 0,0
RVDD_t47 VDD__t47 VDD 928.909964833
* device instance VDD_t48 r0 *1 0,0
RVDD_t48 VDD__t48 VDD 787.970535828
* device instance VDD_t49 r0 *1 0,0
RVDD_t49 VDD__t49 VDD 662.264845174
* device instance VDD_t50 r0 *1 0,0
RVDD_t50 VDD__t50 VDD 261.355847813
* device instance VDD_t51 r0 *1 0,0
RVDD_t51 VDD__t51 VDD 562.107820819
* device instance VDD_t52 r0 *1 0,0
RVDD_t52 VDD__t52 VDD 499.726033074
* device instance VDD_t53 r0 *1 0,0
RVDD_t53 VDD__t53 VDD 823.511751829
* device instance VDD_t54 r0 *1 0,0
RVDD_t54 VDD__t54 VDD 1158.07766235
* device instance VDD_t55 r0 *1 0,0
RVDD_t55 VDD__t55 VDD 1235.25138712
* device instance VDD_t56 r0 *1 0,0
RVDD_t56 VDD__t56 VDD 495.60290548
* device instance VDD_t57 r0 *1 0,0
RVDD_t57 VDD__t57 VDD 894.317659799
* device instance VDD_t58 r0 *1 0,0
RVDD_t58 VDD__t58 VDD 665.292651476
* device instance VDD_t59 r0 *1 0,0
RVDD_t59 VDD__t59 VDD 678.504466216
* device instance VDD_t60 r0 *1 0,0
RVDD_t60 VDD__t60 VDD 703.44392867
* device instance VDD_t61 r0 *1 0,0
RVDD_t61 VDD__t61 VDD 738.924530945
* device instance VDD_t62 r0 *1 0,0
RVDD_t62 VDD__t62 VDD 783.515549063
* device instance VDD_t63 r0 *1 0,0
RVDD_t63 VDD__t63 VDD 835.760025578
* device instance VDD_t64 r0 *1 0,0
RVDD_t64 VDD__t64 VDD 646.488584942
* device instance VDD_t65 r0 *1 0,0
RVDD_t65 VDD__t65 VDD 591.658970413
* device instance VDD_t66 r0 *1 0,0
RVDD_t66 VDD__t66 VDD 546.703059824
* device instance VDD_t67 r0 *1 0,0
RVDD_t67 VDD__t67 VDD 514.217060698
* device instance VDD_t68 r0 *1 0,0
RVDD_t68 VDD__t68 VDD 496.653991171
* device instance VDD_t69 r0 *1 0,0
RVDD_t69 VDD__t69 VDD 708.904574109
* device instance VDD_t70 r0 *1 0,0
RVDD_t70 VDD__t70 VDD 664.508363441
* device instance VDD_t71 r0 *1 0,0
RVDD_t71 VDD__t71 VDD 991.183812156
* device instance VDD_t72 r0 *1 0,0
RVDD_t72 VDD__t72 VDD 969.244024022
* device instance VDD_t73 r0 *1 0,0
RVDD_t73 VDD__t73 VDD 1011.15979263
* device instance VDD_t74 r0 *1 0,0
RVDD_t74 VDD__t74 VDD 991.183812156
* device instance VDD_t75 r0 *1 0,0
RVDD_t75 VDD__t75 VDD 969.244024022
* device instance VDD_t76 r0 *1 0,0
RVDD_t76 VDD__t76 VDD 1011.15979263
* device instance VDD_t77 r0 *1 0,0
RVDD_t77 VDD__t77 VDD 479.531831221
* device instance VDD_t78 r0 *1 0,0
RVDD_t78 VDD__t78 VDD 210.555831562
* device instance VDD_t79 r0 *1 0,0
RVDD_t79 VDD__t79 VDD 167.82624851
* device instance VDD_t80 r0 *1 0,0
RVDD_t80 VDD__t80 VDD 314.994531373
* device instance VDD_t81 r0 *1 0,0
RVDD_t81 VDD__t81 VDD 496.103704552
* device instance VDD_t82 r0 *1 0,0
RVDD_t82 VDD__t82 VDD 660.6976807
* device instance VDD_t83 r0 *1 0,0
RVDD_t83 VDD__t83 VDD 648.346602341
* device instance VDD_t84 r0 *1 0,0
RVDD_t84 VDD__t84 VDD 828.611659433
* device instance VDD_t85 r0 *1 0,0
RVDD_t85 VDD__t85 VDD 990.03956878
* device instance VDD_t86 r0 *1 0,0
RVDD_t86 VDD__t86 VDD 818.79739474
* device instance VDD_t87 r0 *1 0,0
RVDD_t87 VDD__t87 VDD 285.029647144
* device instance VDD_t88 r0 *1 0,0
RVDD_t88 VDD__t88 VDD 255.095651149
* device instance VDD_t89 r0 *1 0,0
RVDD_t89 VDD__t89 VDD 129.549457102
* device instance VDD_t90 r0 *1 0,0
RVDD_t90 VDD__t90 VDD 181.524572307
* device instance VDD_t91 r0 *1 0,0
RVDD_t91 VDD__t91 VDD 339.690540508
* device instance VDD_t92 r0 *1 0,0
RVDD_t92 VDD__t92 VDD 479.531831221
* device instance VDD_t93 r0 *1 0,0
RVDD_t93 VDD__t93 VDD 210.555831562
* device instance VDD_t94 r0 *1 0,0
RVDD_t94 VDD__t94 VDD 167.82624851
* device instance VDD_t95 r0 *1 0,0
RVDD_t95 VDD__t95 VDD 314.994531373
* device instance VDD_t96 r0 *1 0,0
RVDD_t96 VDD__t96 VDD 496.103704552
* device instance VDD_t97 r0 *1 0,0
RVDD_t97 VDD__t97 VDD 660.6976807
* device instance VDD_t98 r0 *1 0,0
RVDD_t98 VDD__t98 VDD 648.346602341
* device instance VDD_t99 r0 *1 0,0
RVDD_t99 VDD__t99 VDD 828.611659433
* device instance VDD_t100 r0 *1 0,0
RVDD_t100 VDD__t100 VDD 990.03956878
* device instance VDD_t101 r0 *1 0,0
RVDD_t101 VDD__t101 VDD 818.79739474
* device instance VDD_t102 r0 *1 0,0
RVDD_t102 VDD__t102 VDD 285.029647144
* device instance VDD_t103 r0 *1 0,0
RVDD_t103 VDD__t103 VDD 255.095651149
* device instance VDD_t104 r0 *1 0,0
RVDD_t104 VDD__t104 VDD 129.549457102
* device instance VDD_t105 r0 *1 0,0
RVDD_t105 VDD__t105 VDD 181.524572307
* device instance VDD_t106 r0 *1 0,0
RVDD_t106 VDD__t106 VDD 339.690540508
* device instance VDD r0 *1 0,0
CVDD VDD vsubs 3.47490616e-13
* device instance VOUT_t0 r0 *1 0,0
RVOUT_t0 VOUT__t0 VOUT 198.482249503
* device instance VOUT_t1 r0 *1 0,0
RVOUT_t1 VOUT__t1 VOUT 52.9477578974
* device instance VOUT_t2 r0 *1 0,0
RVOUT_t2 VOUT__t2 VOUT 215.174940507
* device instance VOUT_t3 r0 *1 0,0
RVOUT_t3 VOUT__t3 VOUT 276.075176241
* device instance VOUT_t4 r0 *1 0,0
RVOUT_t4 VOUT__t4 VOUT 33.5200722328
* device instance VOUT_t5 r0 *1 0,0
RVOUT_t5 VOUT__t5 VOUT 203.355403619
* device instance VOUT r0 *1 0,0
CVOUT VOUT vsubs 3.3307323e-14
* device instance VSS_t0 r0 *1 0,0
RVSS_t0 VSS__t0 VSS 171.593362306
* device instance VSS_t1 r0 *1 0,0
RVSS_t1 VSS__t1 VSS 168.802968344
* device instance VSS_t2 r0 *1 0,0
RVSS_t2 VSS__t2 VSS 166.015940217
* device instance VSS_t3 r0 *1 0,0
RVSS_t3 VSS__t3 VSS 163.232450331
* device instance VSS_t4 r0 *1 0,0
RVSS_t4 VSS__t4 VSS 171.179286884
* device instance VSS_t5 r0 *1 0,0
RVSS_t5 VSS__t5 VSS 168.382031085
* device instance VSS_t6 r0 *1 0,0
RVSS_t6 VSS__t6 VSS 165.58791827
* device instance VSS_t7 r0 *1 0,0
RVSS_t7 VSS__t7 VSS 162.797110269
* device instance VSS_t8 r0 *1 0,0
RVSS_t8 VSS__t8 VSS 213.873915407
* device instance VSS_t9 r0 *1 0,0
RVSS_t9 VSS__t9 VSS 212.168792028
* device instance VSS_t10 r0 *1 0,0
RVSS_t10 VSS__t10 VSS 210.489503491
* device instance VSS_t11 r0 *1 0,0
RVSS_t11 VSS__t11 VSS 208.836673024
* device instance VSS_t12 r0 *1 0,0
RVSS_t12 VSS__t12 VSS 215.196302068
* device instance VSS_t13 r0 *1 0,0
RVSS_t13 VSS__t13 VSS 213.501740141
* device instance VSS_t14 r0 *1 0,0
RVSS_t14 VSS__t14 VSS 211.833018702
* device instance VSS_t15 r0 *1 0,0
RVSS_t15 VSS__t15 VSS 210.190753203
* device instance VSS_t16 r0 *1 0,0
RVSS_t16 VSS__t16 VSS 214.481651992
* device instance VSS_t17 r0 *1 0,0
RVSS_t17 VSS__t17 VSS 221.374418165
* device instance VSS_t18 r0 *1 0,0
RVSS_t18 VSS__t18 VSS 228.275204039
* device instance VSS_t19 r0 *1 0,0
RVSS_t19 VSS__t19 VSS 235.183303671
* device instance VSS_t20 r0 *1 0,0
RVSS_t20 VSS__t20 VSS 213.426261557
* device instance VSS_t21 r0 *1 0,0
RVSS_t21 VSS__t21 VSS 220.352043555
* device instance VSS_t22 r0 *1 0,0
RVSS_t22 VSS__t22 VSS 227.283872855
* device instance VSS_t23 r0 *1 0,0
RVSS_t23 VSS__t23 VSS 234.221212546
* device instance VSS_t24 r0 *1 0,0
RVSS_t24 VSS__t24 VSS 112.516330586
* device instance VSS_t25 r0 *1 0,0
RVSS_t25 VSS__t25 VSS 103.764094632
* device instance VSS_t26 r0 *1 0,0
RVSS_t26 VSS__t26 VSS 95.1834373911
* device instance VSS_t27 r0 *1 0,0
RVSS_t27 VSS__t27 VSS 86.8252434763
* device instance VSS_t28 r0 *1 0,0
RVSS_t28 VSS__t28 VSS 78.7603694017
* device instance VSS_t29 r0 *1 0,0
RVSS_t29 VSS__t29 VSS 71.0887150279
* device instance VSS_t30 r0 *1 0,0
RVSS_t30 VSS__t30 VSS 63.9519487801
* device instance VSS_t31 r0 *1 0,0
RVSS_t31 VSS__t31 VSS 57.5494121054
* device instance VSS_t32 r0 *1 0,0
RVSS_t32 VSS__t32 VSS 52.152225715
* device instance VSS_t33 r0 *1 0,0
RVSS_t33 VSS__t33 VSS 48.1000123994
* device instance VSS_t34 r0 *1 0,0
RVSS_t34 VSS__t34 VSS 111.676896755
* device instance VSS_t35 r0 *1 0,0
RVSS_t35 VSS__t35 VSS 102.85325447
* device instance VSS_t36 r0 *1 0,0
RVSS_t36 VSS__t36 VSS 94.1896564054
* device instance VSS_t37 r0 *1 0,0
RVSS_t37 VSS__t37 VSS 85.734634337
* device instance VSS_t38 r0 *1 0,0
RVSS_t38 VSS__t38 VSS 77.5564337014
* device instance VSS_t39 r0 *1 0,0
RVSS_t39 VSS__t39 VSS 69.7524911705
* device instance VSS_t40 r0 *1 0,0
RVSS_t40 VSS__t40 VSS 62.4632401734
* device instance VSS_t41 r0 *1 0,0
RVSS_t41 VSS__t41 VSS 55.8904236329
* device instance VSS_t42 r0 *1 0,0
RVSS_t42 VSS__t42 VSS 50.3155966596
* device instance VSS_t43 r0 *1 0,0
RVSS_t43 VSS__t43 VSS 46.1022321911
* device instance VSS_t44 r0 *1 0,0
RVSS_t44 VSS__t44 VSS 110.871978323
* device instance VSS_t45 r0 *1 0,0
RVSS_t45 VSS__t45 VSS 101.978714757
* device instance VSS_t46 r0 *1 0,0
RVSS_t46 VSS__t46 VSS 93.2338869842
* device instance VSS_t47 r0 *1 0,0
RVSS_t47 VSS__t47 VSS 84.6834920944
* device instance VSS_t48 r0 *1 0,0
RVSS_t48 VSS__t48 VSS 76.3928446707
* device instance VSS_t49 r0 *1 0,0
RVSS_t49 VSS__t49 VSS 68.4563827039
* device instance VSS_t50 r0 *1 0,0
RVSS_t50 VSS__t50 VSS 61.0124797183
* device instance VSS_t51 r0 *1 0,0
RVSS_t51 VSS__t51 VSS 54.2642217513
* device instance VSS_t52 r0 *1 0,0
RVSS_t52 VSS__t52 VSS 48.5028409026
* device instance VSS_t53 r0 *1 0,0
RVSS_t53 VSS__t53 VSS 44.1166875617
* device instance VSS_t54 r0 *1 0,0
RVSS_t54 VSS__t54 VSS 110.102332282
* device instance VSS_t55 r0 *1 0,0
RVSS_t55 VSS__t55 VSS 101.141417135
* device instance VSS_t56 r0 *1 0,0
RVSS_t56 VSS__t56 VSS 92.3173097465
* device instance VSS_t57 r0 *1 0,0
RVSS_t57 VSS__t57 VSS 83.6733041654
* device instance VSS_t58 r0 *1 0,0
RVSS_t58 VSS__t58 VSS 75.2714734381
* device instance VSS_t59 r0 *1 0,0
RVSS_t59 VSS__t59 VSS 67.2027107307
* device instance VSS_t60 r0 *1 0,0
RVSS_t60 VSS__t60 VSS 59.6024385241
* device instance VSS_t61 r0 *1 0,0
RVSS_t61 VSS__t61 VSS 52.6738432139
* device instance VSS_t62 r0 *1 0,0
RVSS_t62 VSS__t62 VSS 46.7167376031
* device instance VSS_t63 r0 *1 0,0
RVSS_t63 VSS__t63 VSS 42.1451078782
* device instance VSS_t64 r0 *1 0,0
RVSS_t64 VSS__t64 VSS 109.368703287
* device instance VSS_t65 r0 *1 0,0
RVSS_t65 VSS__t65 VSS 100.3422939
* device instance VSS_t66 r0 *1 0,0
RVSS_t66 VSS__t66 VSS 91.4411032507
* device instance VSS_t67 r0 *1 0,0
RVSS_t67 VSS__t67 VSS 82.7055712443
* device instance VSS_t68 r0 *1 0,0
RVSS_t68 VSS__t68 VSS 74.1942342667
* device instance VSS_t69 r0 *1 0,0
RVSS_t69 VSS__t69 VSS 65.9938937663
* device instance VSS_t70 r0 *1 0,0
RVSS_t70 VSS__t70 VSS 58.2360744119
* device instance VSS_t71 r0 *1 0,0
RVSS_t71 VSS__t71 VSS 51.1226314249
* device instance VSS_t72 r0 *1 0,0
RVSS_t72 VSS__t72 VSS 44.9604632667
* device instance VSS_t73 r0 *1 0,0
RVSS_t73 VSS__t73 VSS 40.1895484293
* device instance VSS_t74 r0 *1 0,0
RVSS_t74 VSS__t74 VSS 108.671820781
* device instance VSS_t75 r0 *1 0,0
RVSS_t75 VSS__t75 VSS 99.5822640741
* device instance VSS_t76 r0 *1 0,0
RVSS_t76 VSS__t76 VSS 90.6064387162
* device instance VSS_t77 r0 *1 0,0
RVSS_t77 VSS__t77 VSS 81.7818004691
* device instance VSS_t78 r0 *1 0,0
RVSS_t78 VSS__t78 VSS 73.1630765587
* device instance VSS_t79 r0 *1 0,0
RVSS_t79 VSS__t79 VSS 64.8324408576
* device instance VSS_t80 r0 *1 0,0
RVSS_t80 VSS__t80 VSS 56.916533064
* device instance VSS_t81 r0 *1 0,0
RVSS_t81 VSS__t81 VSS 49.6142602175
* device instance VSS_t82 r0 *1 0,0
RVSS_t82 VSS__t82 VSS 43.2376529229
* device instance VSS_t83 r0 *1 0,0
RVSS_t83 VSS__t83 VSS 38.2524662743
* device instance VSS_t84 r0 *1 0,0
RVSS_t84 VSS__t84 VSS 108.012396017
* device instance VSS_t85 r0 *1 0,0
RVSS_t85 VSS__t85 VSS 98.8622292864
* device instance VSS_t86 r0 *1 0,0
RVSS_t86 VSS__t86 VSS 89.8144743245
* device instance VSS_t87 r0 *1 0,0
RVSS_t87 VSS__t87 VSS 80.903497757
* device instance VSS_t88 r0 *1 0,0
RVSS_t88 VSS__t88 VSS 72.1799752902
* device instance VSS_t89 r0 *1 0,0
RVSS_t89 VSS__t89 VSS 63.7209419964
* device instance VSS_t90 r0 *1 0,0
RVSS_t90 VSS__t90 VSS 55.6471454558
* device instance VSS_t91 r0 *1 0,0
RVSS_t91 VSS__t91 VSS 48.1527556665
* device instance VSS_t92 r0 *1 0,0
RVSS_t92 VSS__t92 VSS 41.55246914
* device instance VSS_t93 r0 *1 0,0
RVSS_t93 VSS__t93 VSS 36.336816556
* device instance VSS_t94 r0 *1 0,0
RVSS_t94 VSS__t94 VSS 107.391119013
* device instance VSS_t95 r0 *1 0,0
RVSS_t95 VSS__t95 VSS 98.1830694625
* device instance VSS_t96 r0 *1 0,0
RVSS_t96 VSS__t96 VSS 89.0663491323
* device instance VSS_t97 r0 *1 0,0
RVSS_t97 VSS__t97 VSS 80.0721593246
* device instance VSS_t98 r0 *1 0,0
RVSS_t98 VSS__t98 VSS 71.2469198105
* device instance VSS_t99 r0 *1 0,0
RVSS_t99 VSS__t99 VSS 62.6620554921
* device instance VSS_t100 r0 *1 0,0
RVSS_t100 VSS__t100 VSS 54.4314205855
* device instance VSS_t101 r0 *1 0,0
RVSS_t101 VSS__t101 VSS 46.7425141372
* device instance VSS_t102 r0 *1 0,0
RVSS_t102 VSS__t102 VSS 39.9096785406
* device instance VSS_t103 r0 *1 0,0
RVSS_t103 VSS__t103 VSS 34.4461752159
* device instance VSS_t104 r0 *1 0,0
RVSS_t104 VSS__t104 VSS 106.808655458
* device instance VSS_t105 r0 *1 0,0
RVSS_t105 VSS__t105 VSS 97.5456383796
* device instance VSS_t106 r0 *1 0,0
RVSS_t106 VSS__t106 VSS 88.3631766381
* device instance VSS_t107 r0 *1 0,0
RVSS_t107 VSS__t107 VSS 79.2892624302
* device instance VSS_t108 r0 *1 0,0
RVSS_t108 VSS__t108 VSS 70.3659009769
* device instance VSS_t109 r0 *1 0,0
RVSS_t109 VSS__t109 VSS 61.6584920049
* device instance VSS_t110 r0 *1 0,0
RVSS_t110 VSS__t110 VSS 53.2730324346
* device instance VSS_t111 r0 *1 0,0
RVSS_t111 VSS__t111 VSS 45.3883141975
* device instance VSS_t112 r0 *1 0,0
RVSS_t112 VSS__t112 VSS 38.31473449
* device instance VSS_t113 r0 *1 0,0
RVSS_t113 VSS__t113 VSS 32.5848956547
* device instance VSS_t114 r0 *1 0,0
RVSS_t114 VSS__t114 VSS 87.7060380569
* device instance VSS_t115 r0 *1 0,0
RVSS_t115 VSS__t115 VSS 78.5562554019
* device instance VSS_t116 r0 *1 0,0
RVSS_t116 VSS__t116 VSS 69.5388966432
* device instance VSS_t117 r0 *1 0,0
RVSS_t117 VSS__t117 VSS 60.7129950041
* device instance VSS_t118 r0 *1 0,0
RVSS_t118 VSS__t118 VSS 52.1758000498
* device instance VSS_t119 r0 *1 0,0
RVSS_t119 VSS__t119 VSS 44.0953193859
* device instance VSS_t120 r0 *1 0,0
RVSS_t120 VSS__t120 VSS 36.77386307
* device instance VSS_t121 r0 *1 0,0
RVSS_t121 VSS__t121 VSS 30.758308648
* device instance VSS_t122 r0 *1 0,0
RVSS_t122 VSS__t122 VSS 96.9525494299
* device instance VSS_t123 r0 *1 0,0
RVSS_t123 VSS__t123 VSS 106.267445601
* device instance VSS_t124 r0 *1 0,0
RVSS_t124 VSS__t124 VSS 115.63554765
* device instance VSS_t125 r0 *1 0,0
RVSS_t125 VSS__t125 VSS 125.044897932
* device instance VSS_t126 r0 *1 0,0
RVSS_t126 VSS__t126 VSS 134.486838946
* device instance VSS_t127 r0 *1 0,0
RVSS_t127 VSS__t127 VSS 143.954958
* device instance VSS_t128 r0 *1 0,0
RVSS_t128 VSS__t128 VSS 153.44440931
* device instance VSS_t129 r0 *1 0,0
RVSS_t129 VSS__t129 VSS 37.7107053378
* device instance VSS_t130 r0 *1 0,0
RVSS_t130 VSS__t130 VSS 39.2038968246
* device instance VSS_t131 r0 *1 0,0
RVSS_t131 VSS__t131 VSS 40.8343781001
* device instance VSS_t132 r0 *1 0,0
RVSS_t132 VSS__t132 VSS 42.5863830683
* device instance VSS_t133 r0 *1 0,0
RVSS_t133 VSS__t133 VSS 44.4455429744
* device instance VSS_t134 r0 *1 0,0
RVSS_t134 VSS__t134 VSS 46.3989788376
* device instance VSS_t135 r0 *1 0,0
RVSS_t135 VSS__t135 VSS 48.4352853144
* device instance VSS_t136 r0 *1 0,0
RVSS_t136 VSS__t136 VSS 50.544447462
* device instance VSS_t137 r0 *1 0,0
RVSS_t137 VSS__t137 VSS 52.7177214456
* device instance VSS_t138 r0 *1 0,0
RVSS_t138 VSS__t138 VSS 54.9475005712
* device instance VSS_t139 r0 *1 0,0
RVSS_t139 VSS__t139 VSS 35.8925068317
* device instance VSS_t140 r0 *1 0,0
RVSS_t140 VSS__t140 VSS 37.4582471002
* device instance VSS_t141 r0 *1 0,0
RVSS_t141 VSS__t141 VSS 39.161475769
* device instance VSS_t142 r0 *1 0,0
RVSS_t142 VSS__t142 VSS 40.9850554767
* device instance VSS_t143 r0 *1 0,0
RVSS_t143 VSS__t143 VSS 42.913646313
* device instance VSS_t144 r0 *1 0,0
RVSS_t144 VSS__t144 VSS 44.9337288322
* device instance VSS_t145 r0 *1 0,0
RVSS_t145 VSS__t145 VSS 47.0335158486
* device instance VSS_t146 r0 *1 0,0
RVSS_t146 VSS__t146 VSS 49.2028039732
* device instance VSS_t147 r0 *1 0,0
RVSS_t147 VSS__t147 VSS 51.4327998849
* device instance VSS_t148 r0 *1 0,0
RVSS_t148 VSS__t148 VSS 53.7159433373
* device instance VSS_t149 r0 *1 0,0
RVSS_t149 VSS__t149 VSS 34.1102401704
* device instance VSS_t150 r0 *1 0,0
RVSS_t150 VSS__t150 VSS 35.7541146393
* device instance VSS_t151 r0 *1 0,0
RVSS_t151 VSS__t151 VSS 37.5347521935
* device instance VSS_t152 r0 *1 0,0
RVSS_t152 VSS__t152 VSS 39.4336304472
* device instance VSS_t153 r0 *1 0,0
RVSS_t153 VSS__t153 VSS 41.4344962284
* device instance VSS_t154 r0 *1 0,0
RVSS_t154 VSS__t154 VSS 43.523286004
* device instance VSS_t155 r0 *1 0,0
RVSS_t155 VSS__t155 VSS 45.6879420734
* device instance VSS_t156 r0 *1 0,0
RVSS_t156 VSS__t156 VSS 47.9181839873
* device instance VSS_t157 r0 *1 0,0
RVSS_t157 VSS__t157 VSS 50.2052720521
* device instance VSS_t158 r0 *1 0,0
RVSS_t158 VSS__t158 VSS 52.5417834341
* device instance VSS_t159 r0 *1 0,0
RVSS_t159 VSS__t159 VSS 32.3698410644
* device instance VSS_t160 r0 *1 0,0
RVSS_t160 VSS__t160 VSS 34.0977248463
* device instance VSS_t161 r0 *1 0,0
RVSS_t161 VSS__t161 VSS 35.9604748061
* device instance VSS_t162 r0 *1 0,0
RVSS_t162 VSS__t162 VSS 37.9382305373
* device instance VSS_t163 r0 *1 0,0
RVSS_t163 VSS__t163 VSS 40.013942617
* device instance VSS_t164 r0 *1 0,0
RVSS_t164 VSS__t164 VSS 42.173149641
* device instance VSS_t165 r0 *1 0,0
RVSS_t165 VSS__t165 VSS 44.403673012
* device instance VSS_t166 r0 *1 0,0
RVSS_t166 VSS__t166 VSS 46.6952940102
* device instance VSS_t167 r0 *1 0,0
RVSS_t167 VSS__t167 VSS 49.0394480788
* device instance VSS_t168 r0 *1 0,0
RVSS_t168 VSS__t168 VSS 51.4289522787
* device instance VSS_t169 r0 *1 0,0
RVSS_t169 VSS__t169 VSS 94.6575215411
* device instance VSS_t170 r0 *1 0,0
RVSS_t170 VSS__t170 VSS 125.329036357
* device instance VSS_t171 r0 *1 0,0
RVSS_t171 VSS__t171 VSS 156.653877857
* device instance VSS_t172 r0 *1 0,0
RVSS_t172 VSS__t172 VSS 188.306284187
* device instance VSS_t173 r0 *1 0,0
RVSS_t173 VSS__t173 VSS 100.264986984
* device instance VSS_t174 r0 *1 0,0
RVSS_t174 VSS__t174 VSS 129.616312958
* device instance VSS_t175 r0 *1 0,0
RVSS_t175 VSS__t175 VSS 160.104524228
* device instance VSS_t176 r0 *1 0,0
RVSS_t176 VSS__t176 VSS 191.186500295
* device instance VSS_t177 r0 *1 0,0
RVSS_t177 VSS__t177 VSS 174.097052032
* device instance VSS_t178 r0 *1 0,0
RVSS_t178 VSS__t178 VSS 199.489041577
* device instance VSS_t179 r0 *1 0,0
RVSS_t179 VSS__t179 VSS 226.644481548
* device instance VSS_t180 r0 *1 0,0
RVSS_t180 VSS__t180 VSS 255.0006146
* device instance VSS_t181 r0 *1 0,0
RVSS_t181 VSS__t181 VSS 183.230445745
* device instance VSS_t182 r0 *1 0,0
RVSS_t182 VSS__t182 VSS 207.507808121
* device instance VSS_t183 r0 *1 0,0
RVSS_t183 VSS__t183 VSS 233.733467304
* device instance VSS_t184 r0 *1 0,0
RVSS_t184 VSS__t184 VSS 261.321499629
* device instance VSS_t185 r0 *1 0,0
RVSS_t185 VSS__t185 VSS 252.666850787
* device instance VSS_t186 r0 *1 0,0
RVSS_t186 VSS__t186 VSS 219.283426727
* device instance VSS_t187 r0 *1 0,0
RVSS_t187 VSS__t187 VSS 268.497209738
* device instance VSS_t188 r0 *1 0,0
RVSS_t188 VSS__t188 VSS 171.593362306
* device instance VSS_t189 r0 *1 0,0
RVSS_t189 VSS__t189 VSS 214.481651992
* device instance VSS_t190 r0 *1 0,0
RVSS_t190 VSS__t190 VSS 94.6575215411
* device instance VSS_t191 r0 *1 0,0
RVSS_t191 VSS__t191 VSS 219.283426727
* device instance VSS_t192 r0 *1 0,0
RVSS_t192 VSS__t192 VSS 255.0006146
* device instance VSS_t193 r0 *1 0,0
RVSS_t193 VSS__t193 VSS 174.097052032
* device instance VSS_t194 r0 *1 0,0
RVSS_t194 VSS__t194 VSS 226.644481548
* device instance VSS_t195 r0 *1 0,0
RVSS_t195 VSS__t195 VSS 183.230445745
* device instance VSS_t196 r0 *1 0,0
RVSS_t196 VSS__t196 VSS 207.507808121
* device instance VSS_t197 r0 *1 0,0
RVSS_t197 VSS__t197 VSS 233.733467304
* device instance VSS_t198 r0 *1 0,0
RVSS_t198 VSS__t198 VSS 261.321499629
* device instance VSS_t199 r0 *1 0,0
RVSS_t199 VSS__t199 VSS 125.329036357
* device instance VSS_t200 r0 *1 0,0
RVSS_t200 VSS__t200 VSS 156.653877857
* device instance VSS_t201 r0 *1 0,0
RVSS_t201 VSS__t201 VSS 188.306284187
* device instance VSS_t202 r0 *1 0,0
RVSS_t202 VSS__t202 VSS 100.264986984
* device instance VSS_t203 r0 *1 0,0
RVSS_t203 VSS__t203 VSS 129.616312958
* device instance VSS_t204 r0 *1 0,0
RVSS_t204 VSS__t204 VSS 160.104524228
* device instance VSS_t205 r0 *1 0,0
RVSS_t205 VSS__t205 VSS 191.186500295
* device instance VSS_t206 r0 *1 0,0
RVSS_t206 VSS__t206 VSS 199.489041577
* device instance VSS_t207 r0 *1 0,0
RVSS_t207 VSS__t207 VSS 234.221212546
* device instance VSS_t208 r0 *1 0,0
RVSS_t208 VSS__t208 VSS 220.352043555
* device instance VSS_t209 r0 *1 0,0
RVSS_t209 VSS__t209 VSS 213.426261557
* device instance VSS_t210 r0 *1 0,0
RVSS_t210 VSS__t210 VSS 235.183303671
* device instance VSS_t211 r0 *1 0,0
RVSS_t211 VSS__t211 VSS 228.275204039
* device instance VSS_t212 r0 *1 0,0
RVSS_t212 VSS__t212 VSS 221.374418165
* device instance VSS_t213 r0 *1 0,0
RVSS_t213 VSS__t213 VSS 227.283872855
* device instance VSS_t214 r0 *1 0,0
RVSS_t214 VSS__t214 VSS 165.58791827
* device instance VSS_t215 r0 *1 0,0
RVSS_t215 VSS__t215 VSS 213.873915407
* device instance VSS_t216 r0 *1 0,0
RVSS_t216 VSS__t216 VSS 212.168792028
* device instance VSS_t217 r0 *1 0,0
RVSS_t217 VSS__t217 VSS 210.489503491
* device instance VSS_t218 r0 *1 0,0
RVSS_t218 VSS__t218 VSS 208.836673024
* device instance VSS_t219 r0 *1 0,0
RVSS_t219 VSS__t219 VSS 215.196302068
* device instance VSS_t220 r0 *1 0,0
RVSS_t220 VSS__t220 VSS 213.501740141
* device instance VSS_t221 r0 *1 0,0
RVSS_t221 VSS__t221 VSS 211.833018702
* device instance VSS_t222 r0 *1 0,0
RVSS_t222 VSS__t222 VSS 210.190753203
* device instance VSS_t223 r0 *1 0,0
RVSS_t223 VSS__t223 VSS 168.382031085
* device instance VSS_t224 r0 *1 0,0
RVSS_t224 VSS__t224 VSS 171.179286884
* device instance VSS_t225 r0 *1 0,0
RVSS_t225 VSS__t225 VSS 163.232450331
* device instance VSS_t226 r0 *1 0,0
RVSS_t226 VSS__t226 VSS 166.015940217
* device instance VSS_t227 r0 *1 0,0
RVSS_t227 VSS__t227 VSS 168.802968344
* device instance VSS_t228 r0 *1 0,0
RVSS_t228 VSS__t228 VSS 162.797110269
* device instance VSS r0 *1 0,0
CVSS VSS vsubs 3.2601547e-13
* device instance cc__10__11 r0 *1 0,0
Ccc__10__11 \$10 \$11 2.3023e-17
* device instance cc__10__9 r0 *1 0,0
Ccc__10__9 \$10 \$9 2.3023e-17
* device instance cc__100__111 r0 *1 0,0
Ccc__100__111 \$100 \$111 1.1511e-17
* device instance cc__100__112 r0 *1 0,0
Ccc__100__112 \$100 \$112 2.3023e-17
* device instance cc__101__119 r0 *1 0,0
Ccc__101__119 \$101 \$119 2.3023e-17
* device instance cc__101__97 r0 *1 0,0
Ccc__101__97 \$101 \$97 1.1511e-17
* device instance cc__102__120 r0 *1 0,0
Ccc__102__120 \$102 \$120 2.3023e-17
* device instance cc__102__98 r0 *1 0,0
Ccc__102__98 \$102 \$98 1.1511e-17
* device instance cc__103__104 r0 *1 0,0
Ccc__103__104 \$103 \$104 2.3023e-17
* device instance cc__103__98 r0 *1 0,0
Ccc__103__98 \$103 \$98 2.3023e-17
* device instance cc__104__105 r0 *1 0,0
Ccc__104__105 \$104 \$105 2.3023e-17
* device instance cc__105__106 r0 *1 0,0
Ccc__105__106 \$105 \$106 2.3023e-17
* device instance cc__106__107 r0 *1 0,0
Ccc__106__107 \$106 \$107 2.3023e-17
* device instance cc__107__108 r0 *1 0,0
Ccc__107__108 \$107 \$108 2.3023e-17
* device instance cc__108__109 r0 *1 0,0
Ccc__108__109 \$108 \$109 2.3023e-17
* device instance cc__109__110 r0 *1 0,0
Ccc__109__110 \$109 \$110 2.3023e-17
* device instance cc__11__12 r0 *1 0,0
Ccc__11__12 \$11 \$12 2.3023e-17
* device instance cc__110__99 r0 *1 0,0
Ccc__110__99 \$110 \$99 1.1511e-17
* device instance cc__111__130 r0 *1 0,0
Ccc__111__130 \$111 \$130 2.3023e-17
* device instance cc__112__113 r0 *1 0,0
Ccc__112__113 \$112 \$113 2.3023e-17
* device instance cc__113__114 r0 *1 0,0
Ccc__113__114 \$113 \$114 2.3023e-17
* device instance cc__114__115 r0 *1 0,0
Ccc__114__115 \$114 \$115 2.3023e-17
* device instance cc__115__116 r0 *1 0,0
Ccc__115__116 \$115 \$116 2.3023e-17
* device instance cc__116__117 r0 *1 0,0
Ccc__116__117 \$116 \$117 2.3023e-17
* device instance cc__117__118 r0 *1 0,0
Ccc__117__118 \$117 \$118 2.3023e-17
* device instance cc__118__119 r0 *1 0,0
Ccc__118__119 \$118 \$119 2.3023e-17
* device instance cc__12__13 r0 *1 0,0
Ccc__12__13 \$12 \$13 2.3023e-17
* device instance cc__120__121 r0 *1 0,0
Ccc__120__121 \$120 \$121 2.3023e-17
* device instance cc__121__122 r0 *1 0,0
Ccc__121__122 \$121 \$122 2.3023e-17
* device instance cc__122__123 r0 *1 0,0
Ccc__122__123 \$122 \$123 2.3023e-17
* device instance cc__123__124 r0 *1 0,0
Ccc__123__124 \$123 \$124 2.3023e-17
* device instance cc__124__125 r0 *1 0,0
Ccc__124__125 \$124 \$125 2.3023e-17
* device instance cc__125__126 r0 *1 0,0
Ccc__125__126 \$125 \$126 2.3023e-17
* device instance cc__126__127 r0 *1 0,0
Ccc__126__127 \$126 \$127 2.3023e-17
* device instance cc__127__128 r0 *1 0,0
Ccc__127__128 \$127 \$128 2.3023e-17
* device instance cc__128__129 r0 *1 0,0
Ccc__128__129 \$128 \$129 1.1511e-17
* device instance cc__129__147 r0 *1 0,0
Ccc__129__147 \$129 \$147 1.1511e-17
* device instance cc__13__14 r0 *1 0,0
Ccc__13__14 \$13 \$14 2.3023e-17
* device instance cc__130__131 r0 *1 0,0
Ccc__130__131 \$130 \$131 2.3023e-17
* device instance cc__131__132 r0 *1 0,0
Ccc__131__132 \$131 \$132 2.3023e-17
* device instance cc__132__133 r0 *1 0,0
Ccc__132__133 \$132 \$133 2.3023e-17
* device instance cc__133__134 r0 *1 0,0
Ccc__133__134 \$133 \$134 2.3023e-17
* device instance cc__134__135 r0 *1 0,0
Ccc__134__135 \$134 \$135 2.3023e-17
* device instance cc__135__136 r0 *1 0,0
Ccc__135__136 \$135 \$136 2.3023e-17
* device instance cc__136__137 r0 *1 0,0
Ccc__136__137 \$136 \$137 2.3023e-17
* device instance cc__137__138 r0 *1 0,0
Ccc__137__138 \$137 \$138 2.3023e-17
* device instance cc__138__139 r0 *1 0,0
Ccc__138__139 \$138 \$139 1.1511e-17
* device instance cc__138_VA r0 *1 0,0
Ccc__138_VA \$138 VA 4.5941e-17
* device instance cc__139__157 r0 *1 0,0
Ccc__139__157 \$139 \$157 2.3023e-17
* device instance cc__139_VA r0 *1 0,0
Ccc__139_VA \$139 VA 1.028e-17
* device instance cc__14__15 r0 *1 0,0
Ccc__14__15 \$14 \$15 2.3023e-17
* device instance cc__142__143 r0 *1 0,0
Ccc__142__143 \$142 \$143 2.3023e-17
* device instance cc__142__2 r0 *1 0,0
Ccc__142__2 \$142 \$2 2.3023e-17
* device instance cc__143__144 r0 *1 0,0
Ccc__143__144 \$143 \$144 2.3023e-17
* device instance cc__144__145 r0 *1 0,0
Ccc__144__145 \$144 \$145 2.3023e-17
* device instance cc__145__146 r0 *1 0,0
Ccc__145__146 \$145 \$146 2.3023e-17
* device instance cc__146__147 r0 *1 0,0
Ccc__146__147 \$146 \$147 2.3023e-17
* device instance cc__15__16 r0 *1 0,0
Ccc__15__16 \$15 \$16 1.1511e-17
* device instance cc__150__151 r0 *1 0,0
Ccc__150__151 \$150 \$151 2.3023e-17
* device instance cc__150_VA r0 *1 0,0
Ccc__150_VA \$150 VA 2.3023e-17
* device instance cc__151__152 r0 *1 0,0
Ccc__151__152 \$151 \$152 2.3023e-17
* device instance cc__151_VA r0 *1 0,0
Ccc__151_VA \$151 VA 9.6379e-17
* device instance cc__152__153 r0 *1 0,0
Ccc__152__153 \$152 \$153 2.3023e-17
* device instance cc__153__154 r0 *1 0,0
Ccc__153__154 \$153 \$154 2.3023e-17
* device instance cc__153_VA r0 *1 0,0
Ccc__153_VA \$153 VA 9.6379e-17
* device instance cc__154__155 r0 *1 0,0
Ccc__154__155 \$154 \$155 2.3023e-17
* device instance cc__155__156 r0 *1 0,0
Ccc__155__156 \$155 \$156 2.3023e-17
* device instance cc__155_VA r0 *1 0,0
Ccc__155_VA \$155 VA 9.6379e-17
* device instance cc__156__157 r0 *1 0,0
Ccc__156__157 \$156 \$157 2.3023e-17
* device instance cc__157_VA r0 *1 0,0
Ccc__157_VA \$157 VA 9.6379e-17
* device instance cc__16__30 r0 *1 0,0
Ccc__16__30 \$16 \$30 1.1511e-17
* device instance cc__168__2 r0 *1 0,0
Ccc__168__2 \$168 \$2 2.3023e-17
* device instance cc__168__89 r0 *1 0,0
Ccc__168__89 \$168 \$89 2.3023e-17
* device instance cc__168_VSS r0 *1 0,0
Ccc__168_VSS \$168 VSS 2.0561e-17
* device instance cc__182_GDRV r0 *1 0,0
Ccc__182_GDRV \$182 GDRV 2.3023e-17
* device instance cc__182_NG r0 *1 0,0
Ccc__182_NG \$182 NG 3.3303e-17
* device instance cc__182_VDD r0 *1 0,0
Ccc__182_VDD \$182 VDD 2.9738e-17
* device instance cc__2_VOUT r0 *1 0,0
Ccc__2_VOUT \$2 VOUT 1.028e-17
* device instance cc__2_VSS r0 *1 0,0
Ccc__2_VSS \$2 VSS 2.0561e-17
* device instance cc__21__22 r0 *1 0,0
Ccc__21__22 \$21 \$22 1.1511e-17
* device instance cc__21__23 r0 *1 0,0
Ccc__21__23 \$21 \$23 2.3023e-17
* device instance cc__21_VSS r0 *1 0,0
Ccc__21_VSS \$21 VSS 2.0561e-17
* device instance cc__22__36 r0 *1 0,0
Ccc__22__36 \$22 \$36 2.3023e-17
* device instance cc__23__24 r0 *1 0,0
Ccc__23__24 \$23 \$24 2.3023e-17
* device instance cc__24__25 r0 *1 0,0
Ccc__24__25 \$24 \$25 2.3023e-17
* device instance cc__25__26 r0 *1 0,0
Ccc__25__26 \$25 \$26 2.3023e-17
* device instance cc__26__27 r0 *1 0,0
Ccc__26__27 \$26 \$27 2.3023e-17
* device instance cc__27__28 r0 *1 0,0
Ccc__27__28 \$27 \$28 2.3023e-17
* device instance cc__28__29 r0 *1 0,0
Ccc__28__29 \$28 \$29 2.3023e-17
* device instance cc__29__30 r0 *1 0,0
Ccc__29__30 \$29 \$30 2.3023e-17
* device instance cc__36__37 r0 *1 0,0
Ccc__36__37 \$36 \$37 2.3023e-17
* device instance cc__37__38 r0 *1 0,0
Ccc__37__38 \$37 \$38 2.3023e-17
* device instance cc__38__39 r0 *1 0,0
Ccc__38__39 \$38 \$39 2.3023e-17
* device instance cc__39__40 r0 *1 0,0
Ccc__39__40 \$39 \$40 2.3023e-17
* device instance cc__40__41 r0 *1 0,0
Ccc__40__41 \$40 \$41 2.3023e-17
* device instance cc__41__42 r0 *1 0,0
Ccc__41__42 \$41 \$42 2.3023e-17
* device instance cc__42__43 r0 *1 0,0
Ccc__42__43 \$42 \$43 2.3023e-17
* device instance cc__43__44 r0 *1 0,0
Ccc__43__44 \$43 \$44 2.3023e-17
* device instance cc__44__45 r0 *1 0,0
Ccc__44__45 \$44 \$45 1.1511e-17
* device instance cc__45__55 r0 *1 0,0
Ccc__45__55 \$45 \$55 1.1511e-17
* device instance cc__46__47 r0 *1 0,0
Ccc__46__47 \$46 \$47 1.1511e-17
* device instance cc__46__48 r0 *1 0,0
Ccc__46__48 \$46 \$48 2.3023e-17
* device instance cc__46_VSS r0 *1 0,0
Ccc__46_VSS \$46 VSS 2.0561e-17
* device instance cc__47__56 r0 *1 0,0
Ccc__47__56 \$47 \$56 2.3023e-17
* device instance cc__48__49 r0 *1 0,0
Ccc__48__49 \$48 \$49 2.3023e-17
* device instance cc__49__50 r0 *1 0,0
Ccc__49__50 \$49 \$50 2.3023e-17
* device instance cc__50__51 r0 *1 0,0
Ccc__50__51 \$50 \$51 2.3023e-17
* device instance cc__51__52 r0 *1 0,0
Ccc__51__52 \$51 \$52 2.3023e-17
* device instance cc__52__53 r0 *1 0,0
Ccc__52__53 \$52 \$53 2.3023e-17
* device instance cc__53__54 r0 *1 0,0
Ccc__53__54 \$53 \$54 2.3023e-17
* device instance cc__54__55 r0 *1 0,0
Ccc__54__55 \$54 \$55 2.3023e-17
* device instance cc__56__57 r0 *1 0,0
Ccc__56__57 \$56 \$57 2.3023e-17
* device instance cc__57__58 r0 *1 0,0
Ccc__57__58 \$57 \$58 2.3023e-17
* device instance cc__58__59 r0 *1 0,0
Ccc__58__59 \$58 \$59 2.3023e-17
* device instance cc__59__60 r0 *1 0,0
Ccc__59__60 \$59 \$60 2.3023e-17
* device instance cc__60__61 r0 *1 0,0
Ccc__60__61 \$60 \$61 2.3023e-17
* device instance cc__61__62 r0 *1 0,0
Ccc__61__62 \$61 \$62 2.3023e-17
* device instance cc__62__63 r0 *1 0,0
Ccc__62__63 \$62 \$63 2.3023e-17
* device instance cc__63__64 r0 *1 0,0
Ccc__63__64 \$63 \$64 2.3023e-17
* device instance cc__64__65 r0 *1 0,0
Ccc__64__65 \$64 \$65 1.1511e-17
* device instance cc__65__75 r0 *1 0,0
Ccc__65__75 \$65 \$75 1.1511e-17
* device instance cc__66__67 r0 *1 0,0
Ccc__66__67 \$66 \$67 1.1511e-17
* device instance cc__66__68 r0 *1 0,0
Ccc__66__68 \$66 \$68 2.3023e-17
* device instance cc__66_VSS r0 *1 0,0
Ccc__66_VSS \$66 VSS 2.0561e-17
* device instance cc__67__78 r0 *1 0,0
Ccc__67__78 \$67 \$78 2.3023e-17
* device instance cc__68__69 r0 *1 0,0
Ccc__68__69 \$68 \$69 2.3023e-17
* device instance cc__69__70 r0 *1 0,0
Ccc__69__70 \$69 \$70 2.3023e-17
* device instance cc__7__8 r0 *1 0,0
Ccc__7__8 \$7 \$8 2.3023e-17
* device instance cc__7_VOUT r0 *1 0,0
Ccc__7_VOUT \$7 VOUT 2.3023e-17
* device instance cc__70__71 r0 *1 0,0
Ccc__70__71 \$70 \$71 2.3023e-17
* device instance cc__71__72 r0 *1 0,0
Ccc__71__72 \$71 \$72 2.3023e-17
* device instance cc__72__73 r0 *1 0,0
Ccc__72__73 \$72 \$73 2.3023e-17
* device instance cc__73__74 r0 *1 0,0
Ccc__73__74 \$73 \$74 2.3023e-17
* device instance cc__74__75 r0 *1 0,0
Ccc__74__75 \$74 \$75 2.3023e-17
* device instance cc__78__79 r0 *1 0,0
Ccc__78__79 \$78 \$79 2.3023e-17
* device instance cc__79__80 r0 *1 0,0
Ccc__79__80 \$79 \$80 2.3023e-17
* device instance cc__8__9 r0 *1 0,0
Ccc__8__9 \$8 \$9 2.3023e-17
* device instance cc__80__81 r0 *1 0,0
Ccc__80__81 \$80 \$81 2.3023e-17
* device instance cc__81__82 r0 *1 0,0
Ccc__81__82 \$81 \$82 2.3023e-17
* device instance cc__82__83 r0 *1 0,0
Ccc__82__83 \$82 \$83 2.3023e-17
* device instance cc__83__84 r0 *1 0,0
Ccc__83__84 \$83 \$84 2.3023e-17
* device instance cc__84__85 r0 *1 0,0
Ccc__84__85 \$84 \$85 2.3023e-17
* device instance cc__85__86 r0 *1 0,0
Ccc__85__86 \$85 \$86 2.3023e-17
* device instance cc__86__99 r0 *1 0,0
Ccc__86__99 \$86 \$99 1.1511e-17
* device instance cc__89__90 r0 *1 0,0
Ccc__89__90 \$89 \$90 2.3023e-17
* device instance cc__90__91 r0 *1 0,0
Ccc__90__91 \$90 \$91 2.3023e-17
* device instance cc__91__92 r0 *1 0,0
Ccc__91__92 \$91 \$92 2.3023e-17
* device instance cc__92__93 r0 *1 0,0
Ccc__92__93 \$92 \$93 2.3023e-17
* device instance cc__93__94 r0 *1 0,0
Ccc__93__94 \$93 \$94 2.3023e-17
* device instance cc__94__95 r0 *1 0,0
Ccc__94__95 \$94 \$95 2.3023e-17
* device instance cc__95__96 r0 *1 0,0
Ccc__95__96 \$95 \$96 2.3023e-17
* device instance cc__96__97 r0 *1 0,0
Ccc__96__97 \$96 \$97 2.3023e-17
* device instance cc__98_VSS r0 *1 0,0
Ccc__98_VSS \$98 VSS 2.0561e-17
* device instance cc_D1_D2 r0 *1 0,0
Ccc_D1_D2 D1 D2 3.64878e-16
* device instance cc_D1_GDRV r0 *1 0,0
Ccc_D1_GDRV D1 GDRV 9.3299e-17
* device instance cc_D1_PN r0 *1 0,0
Ccc_D1_PN D1 PN 5.9201e-17
* device instance cc_D1_TAIL r0 *1 0,0
Ccc_D1_TAIL D1 TAIL 2.76273e-16
* device instance cc_D1_VA r0 *1 0,0
Ccc_D1_VA D1 VA 1.18403e-16
* device instance cc_D1_VB r0 *1 0,0
Ccc_D1_VB D1 VB 1.18403e-16
* device instance cc_D1_VDD r0 *1 0,0
Ccc_D1_VDD D1 VDD 6.6606e-17
* device instance cc_D1_VSS r0 *1 0,0
Ccc_D1_VSS D1 VSS 1.635067e-15
* device instance cc_D2_GDRV r0 *1 0,0
Ccc_D2_GDRV D2 GDRV 7.9762e-17
* device instance cc_D2_PN r0 *1 0,0
Ccc_D2_PN D2 PN 5.9201e-17
* device instance cc_D2_TAIL r0 *1 0,0
Ccc_D2_TAIL D2 TAIL 2.76273e-16
* device instance cc_D2_VA r0 *1 0,0
Ccc_D2_VA D2 VA 1.18403e-16
* device instance cc_D2_VB r0 *1 0,0
Ccc_D2_VB D2 VB 7.61419e-16
* device instance cc_D2_VDD r0 *1 0,0
Ccc_D2_VDD D2 VDD 7.8118e-17
* device instance cc_D2_VSS r0 *1 0,0
Ccc_D2_VSS D2 VSS 3.69191e-16
* device instance cc_GDRV_NE r0 *1 0,0
Ccc_GDRV_NE GDRV NE 4.1122e-17
* device instance cc_GDRV_PN r0 *1 0,0
Ccc_GDRV_PN GDRV PN 3.70018e-16
* device instance cc_GDRV_TAIL r0 *1 0,0
Ccc_GDRV_TAIL GDRV TAIL 6.188e-17
* device instance cc_GDRV_VA r0 *1 0,0
Ccc_GDRV_VA GDRV VA 2.0561e-17
* device instance cc_GDRV_VB r0 *1 0,0
Ccc_GDRV_VB GDRV VB 2.0561e-17
* device instance cc_GDRV_VDD r0 *1 0,0
Ccc_GDRV_VDD GDRV VDD 1.272238e-15
* device instance cc_GDRV_VOUT r0 *1 0,0
Ccc_GDRV_VOUT GDRV VOUT 4.1319e-17
* device instance cc_GDRV_VSS r0 *1 0,0
Ccc_GDRV_VSS GDRV VSS 7.98063e-16
* device instance cc_NG_VDD r0 *1 0,0
Ccc_NG_VDD NG VDD 1.7267e-17
* device instance cc_NG_VSS r0 *1 0,0
Ccc_NG_VSS NG VSS 2.0561e-17
* device instance cc_PN_VDD r0 *1 0,0
Ccc_PN_VDD PN VDD 4.26344e-16
* device instance cc_PN_VSS r0 *1 0,0
Ccc_PN_VSS PN VSS 2.25304e-16
* device instance cc_TAIL_VA r0 *1 0,0
Ccc_TAIL_VA TAIL VA 2.15634e-16
* device instance cc_TAIL_VB r0 *1 0,0
Ccc_TAIL_VB TAIL VB 2.10493e-16
* device instance cc_TAIL_VDD r0 *1 0,0
Ccc_TAIL_VDD TAIL VDD 1.8172e-16
* device instance cc_TAIL_VOUT r0 *1 0,0
Ccc_TAIL_VOUT TAIL VOUT 4.6045e-17
* device instance cc_TAIL_VSS r0 *1 0,0
Ccc_TAIL_VSS TAIL VSS 2.0561e-17
* device instance cc_VA_VB r0 *1 0,0
Ccc_VA_VB VA VB 1.030447e-15
* device instance cc_VA_VDD r0 *1 0,0
Ccc_VA_VDD VA VDD 6.6606e-17
* device instance cc_VA_VOUT r0 *1 0,0
Ccc_VA_VOUT VA VOUT 1.028e-17
* device instance cc_VA_VSS r0 *1 0,0
Ccc_VA_VSS VA VSS 1.028e-17
* device instance cc_VB_VDD r0 *1 0,0
Ccc_VB_VDD VB VDD 6.6606e-17
* device instance cc_VBQ_VSS r0 *1 0,0
Ccc_VBQ_VSS VBQ VSS 3.14096e-16
* device instance cc_VDD_VOUT r0 *1 0,0
Ccc_VDD_VOUT VDD VOUT 1.15114e-16
* device instance cc_VDD_VSS r0 *1 0,0
Ccc_VDD_VSS VDD VSS 1.02804e-16
* device instance cc_VOUT_VSS r0 *1 0,0
Ccc_VOUT_VSS VOUT VSS 3.42066e-16
* device instance vsubs_dctie r0 *1 0,0
Rvsubs_dctie vsubs 0 1e+12
.ENDS bandgap_core_routed
