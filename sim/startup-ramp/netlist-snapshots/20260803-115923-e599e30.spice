** sch_path: sim/startup-ramp/testbench/tb_startup_ramp.sch
**.subckt tb_startup_ramp
VSLOW VDDS 0 pwl(0 0 't_slow' 'vsup')
.save i(vslow)
VFAST VDDF 0 pwl(0 0 't_fast' 'vsup')
.save i(vfast)
VDEGN VDDN 0 pwl(0 0 1n 'vsup')
.save i(vdegn)
XSLOW VREFS GS VDDS 0 bandgap_core
XSUS GS VREFS VDDS 0 startup_injector
XFAST VREFF GF VDDF 0 bandgap_core
XSUF GF VREFF VDDF 0 startup_injector
XDEGN VREFN GN VDDN 0 bandgap_core
VDEG VDDG 0 pwl(0 0 1n 'vsup')
.save i(vdeg)
XDEG VREFG GG VDDG 0 bandgap_core
XSUG GG VREFG VDDG 0 startup_injector
**** begin user architecture code

* Put the XDEG copy (injector attached) and the XDEGN control copy (no
* injector) in the degenerate zero-current state at t = 0: their mirror gates
* start at the supply rail, which is where the all-off solution parks them,
* while every other node starts at 0 V (UIC). Nothing holds GG/GN there after
* t = 0 -- .ic only sets the transient's starting point -- so whether either
* circuit leaves that state is decided by the circuit, not by the deck.
.ic v(GG)='vsup' v(GN)='vsup'

**** end user architecture code
**.ends

* expanding   symbol:  design/bandgap_core.sym # of pins=4
** sym_path: design/bandgap_core.sym
** sch_path: design/bandgap_core.sch
.subckt bandgap_core VOUT GDRV VDD VSS
*.opin VOUT
*.iopin GDRV
*.iopin VDD
*.iopin VSS
**** begin user architecture code

* ---- Kuijk core parameters (issue #8) ----
* PNP emitter-area ratio N is built ONLY from paralleled unit devices:
*   N = (n_pnp_ptat * 11.56 um2) / (n_pnp_ctat * 0.4624 um2)
* Keep both counts equal to hold the pair's measured dVBE while lowering the
* per-unit current and sigma(dVBE); raise n_pnp_ptat alone for more PTAT.
.param n_pnp_ctat=8
.param n_pnp_ptat=8
* res_high_po unit segment: W = r_w um, L = r_lseg um (R ~ 380 + 325*L ohm)
.param r_w=1
.param r_lseg=5
* segment counts. K = R2/R1 is set by the integer ratio n_r2/n_r1.
.param n_r1=7
.param n_r2=54
* PMOS mirror multiplicities (unit device W=8u L=2u)
.param m_out=2
.param m_ampbias=2

**** end user architecture code
XMPOUT VOUT GDRV VDD VDD sky130_fd_pr__pfet_g5v0d10v5 L=2 W=8 nf=1 ad=2.32 as=2.32 pd=16.58 ps=16.58 nrd=0.03625 nrs=0.03625 sa=0 sb=0
+ sd=0 mult='m_out' m='m_out'
XMPAMP TAIL GDRV VDD VDD sky130_fd_pr__pfet_g5v0d10v5 L=2 W=8 nf=1 ad=2.32 as=2.32 pd=16.58 ps=16.58 nrd=0.03625 nrs=0.03625 sa=0 sb=0
+ sd=0 mult='m_ampbias' m='m_ampbias'
XAMP VB VA GDRV TAIL VDD VSS error_amp
XR2A VA VOUT VSS sky130_fd_pr__res_high_po W='r_w' L='r_lseg*n_r2' mult=1 m=1
XR2B VB VOUT VSS sky130_fd_pr__res_high_po W='r_w' L='r_lseg*n_r2' mult=1 m=1
XQ1 VSS VSS VA sky130_fd_pr__pnp_05v5_W0p68L0p68 m='n_pnp_ctat' mult='n_pnp_ctat'
XR1 VBQ VB VSS sky130_fd_pr__res_high_po W='r_w' L='r_lseg*n_r1' mult=1 m=1
XQ2 VSS VSS VBQ sky130_fd_pr__pnp_05v5_W3p40L3p40 m='n_pnp_ptat' mult='n_pnp_ptat'
.ends

* expanding   symbol:  design/startup_injector.sym # of pins=4
** sym_path: design/startup_injector.sym
** sch_path: design/startup_injector.sch
.subckt startup_injector GDRV VSENSE VDD VSS
*.iopin GDRV
*.ipin VSENSE
*.iopin VDD
*.iopin VSS
**** begin user architecture code

* ---- startup injector parameters (issue #10) ----
* m_ref  : units of the (W=1 L=20) diode-connected reference PMOS. Raising it
*          raises BOTH the release threshold and the residual current the cell
*          draws from GDRV once disengaged -- the two are the same current.
* m_sense: units of the (W=48 L=0.5) sense NMOS. Raising it lowers the release
*          threshold (better disengage, less traverse margin).
* m_pnp  : unit PNPs in the threshold reference. Raising it lowers VBE at the
*          sense current, i.e. lowers the release threshold.
* m_inj  : units of the (W=10 L=0.5) injector NMOS. Scales the eviction
*          current and the disengaged residual in the same proportion.
.param m_ref=1
.param m_sense=1
.param m_pnp=8
.param m_inj=1

**** end user architecture code
XMPC1 NC1 NC1 GDRV VDD sky130_fd_pr__pfet_g5v0d10v5 L=20 W=1 nf=1 ad=0.29 as=0.29 pd=2.58 ps=2.58 nrd=0.29 nrs=0.29 sa=0 sb=0 sd=0
+ mult='m_ref' m='m_ref'
XMPC2 NG NG NC1 VDD sky130_fd_pr__pfet_g5v0d10v5 L=20 W=1 nf=1 ad=0.29 as=0.29 pd=2.58 ps=2.58 nrd=0.29 nrs=0.29 sa=0 sb=0 sd=0 mult='m_ref'
+ m='m_ref'
XMNS NG VSENSE NE VSS sky130_fd_pr__nfet_g5v0d10v5 L=0.5 W=48 nf=1 ad=13.92 as=13.92 pd=96.58 ps=96.58 nrd=0.00604166666666667 nrs=0.00604166666666667
+ sa=0 sb=0 sd=0 mult='m_sense' m='m_sense'
XQS VSS VSS NE sky130_fd_pr__pnp_05v5_W0p68L0p68 m='m_pnp' mult='m_pnp'
XMNI GDRV NG VSS VSS sky130_fd_pr__nfet_g5v0d10v5 L=0.5 W=10 nf=1 ad=2.9 as=2.9 pd=20.58 ps=20.58 nrd=0.029 nrs=0.029 sa=0 sb=0 sd=0
+ mult='m_inj' m='m_inj'
.ends

* expanding   symbol:  design/error_amp.sym # of pins=6
** sym_path: design/error_amp.sym
** sch_path: design/error_amp.sch
.subckt error_amp VINP VINN AOUT ITAIL VDD VSS
*.ipin VINP
*.ipin VINN
*.opin AOUT
*.iopin ITAIL
*.iopin VDD
*.iopin VSS
**** begin user architecture code

* error-amp device multiplicities (unit device geometry is fixed below)
* amp_m_in    : input-pair PMOS units (W=8u L=2u each)
* amp_m_nmirr : NMOS load/mirror units (W=4u L=2u each)
* amp_m_pmirr : PMOS mirror units (W=8u L=2u each)
.param amp_m_in=2
.param amp_m_nmirr=1
.param amp_m_pmirr=1

**** end user architecture code
XMP1 D1 VINP ITAIL VDD sky130_fd_pr__pfet_g5v0d10v5 L=2 W=8 nf=1 ad=2.32 as=2.32 pd=16.58 ps=16.58 nrd=0.03625 nrs=0.03625 sa=0 sb=0
+ sd=0 mult='amp_m_in' m='amp_m_in'
XMP2 D2 VINN ITAIL VDD sky130_fd_pr__pfet_g5v0d10v5 L=2 W=8 nf=1 ad=2.32 as=2.32 pd=16.58 ps=16.58 nrd=0.03625 nrs=0.03625 sa=0 sb=0
+ sd=0 mult='amp_m_in' m='amp_m_in'
XMN1 D1 D1 VSS VSS sky130_fd_pr__nfet_g5v0d10v5 L=2 W=4 nf=1 ad=1.16 as=1.16 pd=8.58 ps=8.58 nrd=0.0725 nrs=0.0725 sa=0 sb=0 sd=0 mult='amp_m_nmirr'
+ m='amp_m_nmirr'
XMN2 D2 D2 VSS VSS sky130_fd_pr__nfet_g5v0d10v5 L=2 W=4 nf=1 ad=1.16 as=1.16 pd=8.58 ps=8.58 nrd=0.0725 nrs=0.0725 sa=0 sb=0 sd=0 mult='amp_m_nmirr'
+ m='amp_m_nmirr'
XMN3 AOUT D1 VSS VSS sky130_fd_pr__nfet_g5v0d10v5 L=2 W=4 nf=1 ad=1.16 as=1.16 pd=8.58 ps=8.58 nrd=0.0725 nrs=0.0725 sa=0 sb=0 sd=0
+ mult='amp_m_nmirr' m='amp_m_nmirr'
XMN4 PN D2 VSS VSS sky130_fd_pr__nfet_g5v0d10v5 L=2 W=4 nf=1 ad=1.16 as=1.16 pd=8.58 ps=8.58 nrd=0.0725 nrs=0.0725 sa=0 sb=0 sd=0 mult='amp_m_nmirr'
+ m='amp_m_nmirr'
XMP4 AOUT PN VDD VDD sky130_fd_pr__pfet_g5v0d10v5 L=2 W=8 nf=1 ad=2.32 as=2.32 pd=16.58 ps=16.58 nrd=0.03625 nrs=0.03625 sa=0 sb=0
+ sd=0 mult='amp_m_pmirr' m='amp_m_pmirr'
XMP3 PN PN VDD VDD sky130_fd_pr__pfet_g5v0d10v5 L=2 W=8 nf=1 ad=2.32 as=2.32 pd=16.58 ps=16.58 nrd=0.03625 nrs=0.03625 sa=0 sb=0 sd=0
+ mult='amp_m_pmirr' m='amp_m_pmirr'
.ends

.end
