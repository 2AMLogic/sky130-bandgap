** sch_path: sim/startup-stability/testbench/tb_startup_stability.sch
**.subckt tb_startup_stability
V1 VDDA 0 'vsup'
.save i(v1)
V2 VDDB 0 'vsup'
.save i(v2)
V3 VDDC 0 'vsup'
.save i(v3)
V4 VDDD 0 'vsup'
.save i(v4)
XDUT VREFD GD VDDA 0 bandgap_core
XSU GD VREFD VDDA VSSI startup_injector
XREF VREFR GR VDDB 0 bandgap_core
XSW VREFW GSW VDDC 0 bandgap_core
XSUW GSW VREFW VDDC 0 startup_injector
XSWN VREFN GSN VDDD 0 bandgap_core
**** begin user architecture code

* ALPHA is the normalized sweep variable: the runner's dc analysis sweeps
* VALPHA from 0 to 1, and the two B-sources turn that into 0 .. vsup on the
* forced GDRV nodes. VPSW / VPSN are 0 V current probes in series with those
* forcing sources -- i(vpsw) / i(vpsn) are the currents the forcing sources
* have to deliver, i.e. the negated self-currents of the circuits.
VALPHA ALPHA 0 0
BSW NSW 0 V='vsup*v(ALPHA)'
VPSW GSW NSW 0
BSN NSN 0 V='vsup*v(ALPHA)'
VPSN GSN NSN 0
* VPSU is a 0 V probe in XSU's ground return. The injector's VDD pin only
* feeds the two PMOS bulks and its GDRV/VSENSE pins are gates, so every amp
* the disengaged injector draws leaves through this probe: i(vpsu) IS the
* standing current the injector steals from the Iq budget, measured directly
* rather than inferred from the difference of two ~31 uA supply currents
* (which the solver's own tolerance would swamp at the nA level).
VPSU VSSI 0 0
.save i(vpsw) i(vpsn) i(vpsu)
* XREF is the bare core with no startup circuit, so its DC solution has to be
* seeded onto the intended branch exactly the way sim/bandgap-smoke/ does --
* that is the whole point of this issue. A .nodeset biases only the initial
* guess and is released before the final Newton iterations, so the reported
* operating point is still a genuine solution. XDUT (core + injector) needs
* no such help, which is itself part of the evidence.
.nodeset v(VREFR)=1.2 v(GR)=2.2

**** end user architecture code
**.ends

* expanding   symbol:  design/bandgap_core.sym # of pins=4
** sym_path: design/bandgap_core.sym
** sch_path: design/bandgap_core.sch
.subckt bandgap_core VOUT GDRV VDD VSS
*.opin VOUT
*.iopin GDRV
*.iopin VDD
*.iopin VSS
**** begin user architecture code

* ---- Kuijk core parameters (issue #8) ----
* PNP emitter-area ratio N is built ONLY from paralleled unit devices:
*   N = (n_pnp_ptat * 11.56 um2) / (n_pnp_ctat * 0.4624 um2)
* Keep both counts equal to hold the pair's measured dVBE while lowering the
* per-unit current and sigma(dVBE); raise n_pnp_ptat alone for more PTAT.
.param n_pnp_ctat=8
.param n_pnp_ptat=8
* res_high_po unit segment: W = r_w um, L = r_lseg um (R ~ 380 + 325*L ohm)
.param r_w=1
.param r_lseg=5
* segment counts. K = R2/R1 is set by the integer ratio n_r2/n_r1.
.param n_r1=7
.param n_r2=54
* PMOS mirror multiplicities (unit device W=8u L=2u)
.param m_out=2
.param m_ampbias=2

**** end user architecture code
XMPOUT VOUT GDRV VDD VDD sky130_fd_pr__pfet_g5v0d10v5 L=2 W=8 nf=1 ad=2.32 as=2.32 pd=16.58 ps=16.58 nrd=0.03625 nrs=0.03625 sa=0 sb=0 sd=0 mult='m_out' m='m_out'
XMPAMP TAIL GDRV VDD VDD sky130_fd_pr__pfet_g5v0d10v5 L=2 W=8 nf=1 ad=2.32 as=2.32 pd=16.58 ps=16.58 nrd=0.03625 nrs=0.03625 sa=0 sb=0 sd=0 mult='m_ampbias' m='m_ampbias'
XAMP VB VA GDRV TAIL VDD VSS error_amp
XR2A VA VOUT VSS sky130_fd_pr__res_high_po W='r_w' L='r_lseg*n_r2' mult=1 m=1
XR2B VB VOUT VSS sky130_fd_pr__res_high_po W='r_w' L='r_lseg*n_r2' mult=1 m=1
XQ1 VSS VSS VA sky130_fd_pr__pnp_05v5_W0p68L0p68 m='n_pnp_ctat' mult='n_pnp_ctat'
XR1 VBQ VB VSS sky130_fd_pr__res_high_po W='r_w' L='r_lseg*n_r1' mult=1 m=1
XQ2 VSS VSS VBQ sky130_fd_pr__pnp_05v5_W3p40L3p40 m='n_pnp_ptat' mult='n_pnp_ptat'
.ends

* expanding   symbol:  design/startup_injector.sym # of pins=4
** sym_path: design/startup_injector.sym
** sch_path: design/startup_injector.sch
.subckt startup_injector GDRV VSENSE VDD VSS
*.iopin GDRV
*.ipin VSENSE
*.iopin VDD
*.iopin VSS
**** begin user architecture code

* ---- startup injector parameters (issue #10) ----
* m_ref  : units of the (W=1 L=20) diode-connected reference PMOS. Raising it
*          raises BOTH the release threshold and the residual current the cell
*          draws from GDRV once disengaged -- the two are the same current.
* m_sense: units of the (W=48 L=0.5) sense NMOS. Raising it lowers the release
*          threshold (better disengage, less traverse margin).
* m_pnp  : unit PNPs in the threshold reference. Raising it lowers VBE at the
*          sense current, i.e. lowers the release threshold.
* m_inj  : units of the (W=10 L=0.5) injector NMOS. Scales the eviction
*          current and the disengaged residual in the same proportion.
.param m_ref=1
.param m_sense=1
.param m_pnp=8
.param m_inj=1

**** end user architecture code
XMPC1 NC1 NC1 GDRV VDD sky130_fd_pr__pfet_g5v0d10v5 L=20 W=1 nf=1 ad=0.29 as=0.29 pd=2.58 ps=2.58 nrd=0.29 nrs=0.29 sa=0 sb=0 sd=0 mult='m_ref' m='m_ref'
XMPC2 NG NG NC1 VDD sky130_fd_pr__pfet_g5v0d10v5 L=20 W=1 nf=1 ad=0.29 as=0.29 pd=2.58 ps=2.58 nrd=0.29 nrs=0.29 sa=0 sb=0 sd=0 mult='m_ref' m='m_ref'
XMNS NG VSENSE NE VSS sky130_fd_pr__nfet_g5v0d10v5 L=0.5 W=48 nf=1 ad=13.92 as=13.92 pd=96.58 ps=96.58 nrd=0.00604166666666667 nrs=0.00604166666666667 sa=0 sb=0 sd=0 mult='m_sense' m='m_sense'
XQS VSS VSS NE sky130_fd_pr__pnp_05v5_W0p68L0p68 m='m_pnp' mult='m_pnp'
XMNI GDRV NG VSS VSS sky130_fd_pr__nfet_g5v0d10v5 L=0.5 W=10 nf=1 ad=2.9 as=2.9 pd=20.58 ps=20.58 nrd=0.029 nrs=0.029 sa=0 sb=0 sd=0 mult='m_inj' m='m_inj'
.ends

* expanding   symbol:  design/error_amp.sym # of pins=6
** sym_path: design/error_amp.sym
** sch_path: design/error_amp.sch
.subckt error_amp VINP VINN AOUT ITAIL VDD VSS
*.ipin VINP
*.ipin VINN
*.opin AOUT
*.iopin ITAIL
*.iopin VDD
*.iopin VSS
**** begin user architecture code

* ---- error-amp device multiplicities (issue #9 sizing) ----
* Unit geometry is fixed on the instances below; mult is the matching axis
* (sigma(Vth) scales as 1/sqrt(W*L*mult) in the PDK's own model).
* amp_m_in    : input-pair PMOS units   (W=20u L=10u each -> 3200 um^2 total)
* amp_m_nmirr : NMOS load/mirror units  (W=8u  L=20u each ->  640 um^2 total)
* amp_m_pmirr : PMOS mirror units       (W=6u  L=20u each ->  960 um^2 total)
* amp_m_cc    : MOS-capacitor units     (W=30u L=20u each -> 9600 um^2 total)
.param amp_m_in=16
.param amp_m_nmirr=4
.param amp_m_pmirr=8
.param amp_m_cc=16

**** end user architecture code
XMP1 D1 VINP ITAIL VDD sky130_fd_pr__pfet_g5v0d10v5 L=10 W=20 nf=1 ad=5.8 as=5.8 pd=40.58 ps=40.58 nrd=0.0145 nrs=0.0145 sa=0 sb=0
+ sd=0 mult='amp_m_in' m='amp_m_in'
XMP2 D2 VINN ITAIL VDD sky130_fd_pr__pfet_g5v0d10v5 L=10 W=20 nf=1 ad=5.8 as=5.8 pd=40.58 ps=40.58 nrd=0.0145 nrs=0.0145 sa=0 sb=0
+ sd=0 mult='amp_m_in' m='amp_m_in'
XMN1 D1 D1 VSS VSS sky130_fd_pr__nfet_g5v0d10v5 L=20 W=8 nf=1 ad=2.32 as=2.32 pd=16.58 ps=16.58 nrd=0.03625 nrs=0.03625 sa=0 sb=0 sd=0
+ mult='amp_m_nmirr' m='amp_m_nmirr'
XMN2 D2 D2 VSS VSS sky130_fd_pr__nfet_g5v0d10v5 L=20 W=8 nf=1 ad=2.32 as=2.32 pd=16.58 ps=16.58 nrd=0.03625 nrs=0.03625 sa=0 sb=0 sd=0
+ mult='amp_m_nmirr' m='amp_m_nmirr'
XMN3 AOUT D1 VSS VSS sky130_fd_pr__nfet_g5v0d10v5 L=20 W=8 nf=1 ad=2.32 as=2.32 pd=16.58 ps=16.58 nrd=0.03625 nrs=0.03625 sa=0 sb=0
+ sd=0 mult='amp_m_nmirr' m='amp_m_nmirr'
XMN4 PN D2 VSS VSS sky130_fd_pr__nfet_g5v0d10v5 L=20 W=8 nf=1 ad=2.32 as=2.32 pd=16.58 ps=16.58 nrd=0.03625 nrs=0.03625 sa=0 sb=0 sd=0
+ mult='amp_m_nmirr' m='amp_m_nmirr'
XMP4 AOUT PN VDD VDD sky130_fd_pr__pfet_g5v0d10v5 L=20 W=6 nf=1 ad=1.74 as=1.74 pd=12.58 ps=12.58 nrd=0.0483333333333333 nrs=0.0483333333333333
+ sa=0 sb=0 sd=0 mult='amp_m_pmirr' m='amp_m_pmirr'
XMP3 PN PN VDD VDD sky130_fd_pr__pfet_g5v0d10v5 L=20 W=6 nf=1 ad=1.74 as=1.74 pd=12.58 ps=12.58 nrd=0.0483333333333333 nrs=0.0483333333333333
+ sa=0 sb=0 sd=0 mult='amp_m_pmirr' m='amp_m_pmirr'
XMCC VDD AOUT VDD VDD sky130_fd_pr__pfet_g5v0d10v5 L=20 W=30 nf=1 ad=8.7 as=8.7 pd=60.58 ps=60.58 nrd=0.00966666666666667 nrs=0.00966666666666667
+ sa=0 sb=0 sd=0 mult='amp_m_cc' m='amp_m_cc'
.ends

.end
