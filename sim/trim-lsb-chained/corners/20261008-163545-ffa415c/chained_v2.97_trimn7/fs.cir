* klt sim -- generated corner deck, do not edit
.lib /opt/pdk/sky130A/libs.tech/combined/sky130.lib.spice fs
.include /var/tmp/eda-job-klt-sim-6b68d1eb98fa/inputs/netlist.cir
.temp 27
.meas dc vref_27 FIND v(vref) AT=27
.meas dc vref_min MIN v(vref)
.meas dc vref_max MAX v(vref)
.control
dc temp -40 125 11
quit
.endc
.end
