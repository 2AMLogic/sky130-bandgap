** sch_path: design/error_amp.sch
**.subckt error_amp VINP VINN AOUT ITAIL VDD VSS
*.ipin VINP
*.ipin VINN
*.opin AOUT
*.iopin ITAIL
*.iopin VDD
*.iopin VSS
XMP1 D1 VINP ITAIL VDD sky130_fd_pr__pfet_g5v0d10v5 L=10 W=20 nf=1 ad=5.8 as=5.8 pd=40.58 ps=40.58 nrd=0.0145 nrs=0.0145 sa=0 sb=0
+ sd=0 mult='amp_m_in' m='amp_m_in'
XMP2 D2 VINN ITAIL VDD sky130_fd_pr__pfet_g5v0d10v5 L=10 W=20 nf=1 ad=5.8 as=5.8 pd=40.58 ps=40.58 nrd=0.0145 nrs=0.0145 sa=0 sb=0
+ sd=0 mult='amp_m_in' m='amp_m_in'
XMN1 D1 D1 VSS VSS sky130_fd_pr__nfet_g5v0d10v5 L=20 W=8 nf=1 ad=2.32 as=2.32 pd=16.58 ps=16.58 nrd=0.03625 nrs=0.03625 sa=0 sb=0 sd=0
+ mult='amp_m_nmirr' m='amp_m_nmirr'
XMN2 D2 D2 VSS VSS sky130_fd_pr__nfet_g5v0d10v5 L=20 W=8 nf=1 ad=2.32 as=2.32 pd=16.58 ps=16.58 nrd=0.03625 nrs=0.03625 sa=0 sb=0 sd=0
+ mult='amp_m_nmirr' m='amp_m_nmirr'
XMN3 AOUT D1 VSS VSS sky130_fd_pr__nfet_g5v0d10v5 L=20 W=8 nf=1 ad=2.32 as=2.32 pd=16.58 ps=16.58 nrd=0.03625 nrs=0.03625 sa=0 sb=0
+ sd=0 mult='amp_m_nmirr' m='amp_m_nmirr'
XMN4 PN D2 VSS VSS sky130_fd_pr__nfet_g5v0d10v5 L=20 W=8 nf=1 ad=2.32 as=2.32 pd=16.58 ps=16.58 nrd=0.03625 nrs=0.03625 sa=0 sb=0 sd=0
+ mult='amp_m_nmirr' m='amp_m_nmirr'
XMP4 AOUT PN VDD VDD sky130_fd_pr__pfet_g5v0d10v5 L=20 W=6 nf=1 ad=1.74 as=1.74 pd=12.58 ps=12.58 nrd=0.0483333333333333 nrs=0.0483333333333333
+ sa=0 sb=0 sd=0 mult='amp_m_pmirr' m='amp_m_pmirr'
XMP3 PN PN VDD VDD sky130_fd_pr__pfet_g5v0d10v5 L=20 W=6 nf=1 ad=1.74 as=1.74 pd=12.58 ps=12.58 nrd=0.0483333333333333 nrs=0.0483333333333333
+ sa=0 sb=0 sd=0 mult='amp_m_pmirr' m='amp_m_pmirr'
XMCC VDD AOUT VDD VDD sky130_fd_pr__pfet_g5v0d10v5 L=20 W=30 nf=1 ad=8.7 as=8.7 pd=60.58 ps=60.58 nrd=0.00966666666666667 nrs=0.00966666666666667
+ sa=0 sb=0 sd=0 mult='amp_m_cc' m='amp_m_cc'
**** begin user architecture code

* ---- error-amp device multiplicities (issue #9 sizing, amp_m_in revised by #170) ----
* Unit geometry is fixed on the instances below; mult is the matching axis
* (sigma(Vth) scales as 1/sqrt(W*L*mult) in the PDK's own model).
* amp_m_in    : input-pair PMOS units   (W=20u L=10u each -> 1600 um^2 total;
*               16 -> 8 by issue #170, DR-008 Option B PSRR margin increase
*               -- see the header's amp_m_in: 16 -> 8 section)
* amp_m_nmirr : NMOS load/mirror units  (W=8u  L=20u each ->  640 um^2 total)
* amp_m_pmirr : PMOS mirror units       (W=6u  L=20u each ->  960 um^2 total)
* amp_m_cc    : MOS-capacitor units     (W=30u L=20u each -> 9600 um^2 total)
.param amp_m_in=8
.param amp_m_nmirr=4
.param amp_m_pmirr=8
.param amp_m_cc=16

**** end user architecture code
**.ends
.end
