* extracted by klt extract --deck sky130

* cell bandgap_core_routed
* pin D1
* pin D2
* pin GDRV
* pin NE
* pin NG
* pin PN
* pin TAIL
* pin VA
* pin VB
* pin VBQ
* pin VDD
* pin VOUT
* pin VSS
.SUBCKT bandgap_core_routed D1 D2 GDRV NE NG PN TAIL VA VB VBQ VDD VOUT VSS
* device instance $1 r0 *1 180.13,52.67 nfet
X$1 VSS D1 D1 VSS sky130_fd_pr__nfet_01v8 L=20 W=8 AS=3.36 AD=3.36 PS=16.84
+ PD=16.84
* device instance $2 r0 *1 201.37,52.67 nfet
X$2 VSS D2 D2 VSS sky130_fd_pr__nfet_01v8 L=20 W=8 AS=3.36 AD=3.36 PS=16.84
+ PD=16.84
* device instance $3 r0 *1 222.61,52.67 nfet
X$3 VSS D1 D1 VSS sky130_fd_pr__nfet_01v8 L=20 W=8 AS=3.36 AD=3.36 PS=16.84
+ PD=16.84
* device instance $4 r0 *1 243.85,52.67 nfet
X$4 VSS D2 D2 VSS sky130_fd_pr__nfet_01v8 L=20 W=8 AS=3.36 AD=3.36 PS=16.84
+ PD=16.84
* device instance $5 r0 *1 180.13,61.49 nfet
X$5 VSS D2 D2 VSS sky130_fd_pr__nfet_01v8 L=20 W=8 AS=3.36 AD=3.36 PS=16.84
+ PD=16.84
* device instance $6 r0 *1 201.37,61.49 nfet
X$6 VSS D1 D1 VSS sky130_fd_pr__nfet_01v8 L=20 W=8 AS=3.36 AD=3.36 PS=16.84
+ PD=16.84
* device instance $7 r0 *1 222.61,61.49 nfet
X$7 VSS D2 D2 VSS sky130_fd_pr__nfet_01v8 L=20 W=8 AS=3.36 AD=3.36 PS=16.84
+ PD=16.84
* device instance $8 r0 *1 243.85,61.49 nfet
X$8 VSS D1 D1 VSS sky130_fd_pr__nfet_01v8 L=20 W=8 AS=3.36 AD=3.36 PS=16.84
+ PD=16.84
* device instance $9 r0 *1 208.02,105.9 nfet
X$9 VSS D2 PN VSS sky130_fd_pr__nfet_01v8 L=20 W=8 AS=3.36 AD=3.36 PS=16.84
+ PD=16.84
* device instance $10 r0 *1 229.26,105.9 nfet
X$10 VSS D1 GDRV VSS sky130_fd_pr__nfet_01v8 L=20 W=8 AS=3.36 AD=3.36 PS=16.84
+ PD=16.84
* device instance $11 r0 *1 250.5,105.9 nfet
X$11 VSS D2 PN VSS sky130_fd_pr__nfet_01v8 L=20 W=8 AS=3.36 AD=3.36 PS=16.84
+ PD=16.84
* device instance $12 r0 *1 271.74,105.9 nfet
X$12 VSS D1 GDRV VSS sky130_fd_pr__nfet_01v8 L=20 W=8 AS=3.36 AD=3.36 PS=16.84
+ PD=16.84
* device instance $13 r0 *1 208.02,114.72 nfet
X$13 VSS D1 GDRV VSS sky130_fd_pr__nfet_01v8 L=20 W=8 AS=3.36 AD=3.36 PS=16.84
+ PD=16.84
* device instance $14 r0 *1 229.26,114.72 nfet
X$14 VSS D2 PN VSS sky130_fd_pr__nfet_01v8 L=20 W=8 AS=3.36 AD=3.36 PS=16.84
+ PD=16.84
* device instance $15 r0 *1 250.5,114.72 nfet
X$15 VSS D1 GDRV VSS sky130_fd_pr__nfet_01v8 L=20 W=8 AS=3.36 AD=3.36 PS=16.84
+ PD=16.84
* device instance $16 r0 *1 271.74,114.72 nfet
X$16 VSS D2 PN VSS sky130_fd_pr__nfet_01v8 L=20 W=8 AS=3.36 AD=3.36 PS=16.84
+ PD=16.84
* device instance $17 r0 *1 0.92,144.06 nfet
X$17 VDD VOUT GDRV VSS sky130_fd_pr__nfet_01v8 L=1 W=4 AS=1.68 AD=1.68 PS=8.84
+ PD=8.84
* device instance $18 r0 *1 103.77,173.34 nfet
X$18 GDRV NG VSS VSS sky130_fd_pr__nfet_01v8 L=0.5 W=10 AS=4.2 AD=4.2 PS=20.84
+ PD=20.84
* device instance $19 r0 *1 18.51,173.34 nfet
X$19 NG VOUT NE VSS sky130_fd_pr__nfet_01v8 L=0.5 W=48 AS=20.16 AD=20.16
+ PS=96.84 PD=96.84
* device instance $20 r0 *1 67.62,46.67 pfet
X$20 D2 VA TAIL VDD sky130_fd_pr__pfet_01v8 L=10 W=20 AS=8.4 AD=8.4 PS=40.84
+ PD=40.84
* device instance $21 r0 *1 78.86,46.67 pfet
X$21 D1 VB TAIL VDD sky130_fd_pr__pfet_01v8 L=10 W=20 AS=8.4 AD=8.4 PS=40.84
+ PD=40.84
* device instance $22 r0 *1 90.1,46.67 pfet
X$22 D2 VA TAIL VDD sky130_fd_pr__pfet_01v8 L=10 W=20 AS=8.4 AD=8.4 PS=40.84
+ PD=40.84
* device instance $23 r0 *1 101.34,46.67 pfet
X$23 D1 VB TAIL VDD sky130_fd_pr__pfet_01v8 L=10 W=20 AS=8.4 AD=8.4 PS=40.84
+ PD=40.84
* device instance $24 r0 *1 112.58,46.67 pfet
X$24 D2 VA TAIL VDD sky130_fd_pr__pfet_01v8 L=10 W=20 AS=8.4 AD=8.4 PS=40.84
+ PD=40.84
* device instance $25 r0 *1 123.82,46.67 pfet
X$25 D1 VB TAIL VDD sky130_fd_pr__pfet_01v8 L=10 W=20 AS=8.4 AD=8.4 PS=40.84
+ PD=40.84
* device instance $26 r0 *1 135.06,46.67 pfet
X$26 D2 VA TAIL VDD sky130_fd_pr__pfet_01v8 L=10 W=20 AS=8.4 AD=8.4 PS=40.84
+ PD=40.84
* device instance $27 r0 *1 146.3,46.67 pfet
X$27 D1 VB TAIL VDD sky130_fd_pr__pfet_01v8 L=10 W=20 AS=8.4 AD=8.4 PS=40.84
+ PD=40.84
* device instance $28 r0 *1 39.4,61.49 pfet
X$28 TAIL GDRV VDD VDD sky130_fd_pr__pfet_01v8 L=2 W=8 AS=3.36 AD=3.36 PS=16.84
+ PD=16.84
* device instance $29 r0 *1 39.4,52.67 pfet
X$29 VOUT GDRV VDD VDD sky130_fd_pr__pfet_01v8 L=2 W=8 AS=3.36 AD=3.36 PS=16.84
+ PD=16.84
* device instance $30 r0 *1 42.64,61.49 pfet
X$30 VOUT GDRV VDD VDD sky130_fd_pr__pfet_01v8 L=2 W=8 AS=3.36 AD=3.36 PS=16.84
+ PD=16.84
* device instance $31 r0 *1 42.64,52.67 pfet
X$31 TAIL GDRV VDD VDD sky130_fd_pr__pfet_01v8 L=2 W=8 AS=3.36 AD=3.36 PS=16.84
+ PD=16.84
* device instance $32 r0 *1 67.62,67.49 pfet
X$32 D1 VB TAIL VDD sky130_fd_pr__pfet_01v8 L=10 W=20 AS=8.4 AD=8.4 PS=40.84
+ PD=40.84
* device instance $33 r0 *1 78.86,67.49 pfet
X$33 D2 VA TAIL VDD sky130_fd_pr__pfet_01v8 L=10 W=20 AS=8.4 AD=8.4 PS=40.84
+ PD=40.84
* device instance $34 r0 *1 90.1,67.49 pfet
X$34 D1 VB TAIL VDD sky130_fd_pr__pfet_01v8 L=10 W=20 AS=8.4 AD=8.4 PS=40.84
+ PD=40.84
* device instance $35 r0 *1 101.34,67.49 pfet
X$35 D2 VA TAIL VDD sky130_fd_pr__pfet_01v8 L=10 W=20 AS=8.4 AD=8.4 PS=40.84
+ PD=40.84
* device instance $36 r0 *1 112.58,67.49 pfet
X$36 D1 VB TAIL VDD sky130_fd_pr__pfet_01v8 L=10 W=20 AS=8.4 AD=8.4 PS=40.84
+ PD=40.84
* device instance $37 r0 *1 123.82,67.49 pfet
X$37 D2 VA TAIL VDD sky130_fd_pr__pfet_01v8 L=10 W=20 AS=8.4 AD=8.4 PS=40.84
+ PD=40.84
* device instance $38 r0 *1 135.06,67.49 pfet
X$38 D1 VB TAIL VDD sky130_fd_pr__pfet_01v8 L=10 W=20 AS=8.4 AD=8.4 PS=40.84
+ PD=40.84
* device instance $39 r0 *1 146.3,67.49 pfet
X$39 D2 VA TAIL VDD sky130_fd_pr__pfet_01v8 L=10 W=20 AS=8.4 AD=8.4 PS=40.84
+ PD=40.84
* device instance $40 r0 *1 20.51,106.9 pfet
X$40 PN PN VDD VDD sky130_fd_pr__pfet_01v8 L=20 W=6 AS=2.52 AD=2.52 PS=12.84
+ PD=12.84
* device instance $41 r0 *1 20.51,113.72 pfet
X$41 GDRV PN VDD VDD sky130_fd_pr__pfet_01v8 L=20 W=6 AS=2.52 AD=2.52 PS=12.84
+ PD=12.84
* device instance $42 r0 *1 41.75,113.72 pfet
X$42 PN PN VDD VDD sky130_fd_pr__pfet_01v8 L=20 W=6 AS=2.52 AD=2.52 PS=12.84
+ PD=12.84
* device instance $43 r0 *1 41.75,106.9 pfet
X$43 GDRV PN VDD VDD sky130_fd_pr__pfet_01v8 L=20 W=6 AS=2.52 AD=2.52 PS=12.84
+ PD=12.84
* device instance $44 r0 *1 62.99,113.72 pfet
X$44 GDRV PN VDD VDD sky130_fd_pr__pfet_01v8 L=20 W=6 AS=2.52 AD=2.52 PS=12.84
+ PD=12.84
* device instance $45 r0 *1 62.99,106.9 pfet
X$45 PN PN VDD VDD sky130_fd_pr__pfet_01v8 L=20 W=6 AS=2.52 AD=2.52 PS=12.84
+ PD=12.84
* device instance $46 r0 *1 84.23,106.9 pfet
X$46 GDRV PN VDD VDD sky130_fd_pr__pfet_01v8 L=20 W=6 AS=2.52 AD=2.52 PS=12.84
+ PD=12.84
* device instance $47 r0 *1 84.23,113.72 pfet
X$47 PN PN VDD VDD sky130_fd_pr__pfet_01v8 L=20 W=6 AS=2.52 AD=2.52 PS=12.84
+ PD=12.84
* device instance $48 r0 *1 105.47,106.9 pfet
X$48 PN PN VDD VDD sky130_fd_pr__pfet_01v8 L=20 W=6 AS=2.52 AD=2.52 PS=12.84
+ PD=12.84
* device instance $49 r0 *1 105.47,113.72 pfet
X$49 GDRV PN VDD VDD sky130_fd_pr__pfet_01v8 L=20 W=6 AS=2.52 AD=2.52 PS=12.84
+ PD=12.84
* device instance $50 r0 *1 126.71,106.9 pfet
X$50 GDRV PN VDD VDD sky130_fd_pr__pfet_01v8 L=20 W=6 AS=2.52 AD=2.52 PS=12.84
+ PD=12.84
* device instance $51 r0 *1 126.71,113.72 pfet
X$51 PN PN VDD VDD sky130_fd_pr__pfet_01v8 L=20 W=6 AS=2.52 AD=2.52 PS=12.84
+ PD=12.84
* device instance $52 r0 *1 147.95,106.9 pfet
X$52 PN PN VDD VDD sky130_fd_pr__pfet_01v8 L=20 W=6 AS=2.52 AD=2.52 PS=12.84
+ PD=12.84
* device instance $53 r0 *1 147.95,113.72 pfet
X$53 GDRV PN VDD VDD sky130_fd_pr__pfet_01v8 L=20 W=6 AS=2.52 AD=2.52 PS=12.84
+ PD=12.84
* device instance $54 r0 *1 169.19,113.72 pfet
X$54 PN PN VDD VDD sky130_fd_pr__pfet_01v8 L=20 W=6 AS=2.52 AD=2.52 PS=12.84
+ PD=12.84
* device instance $55 r0 *1 169.19,106.9 pfet
X$55 GDRV PN VDD VDD sky130_fd_pr__pfet_01v8 L=20 W=6 AS=2.52 AD=2.52 PS=12.84
+ PD=12.84
* device instance $56 r0 *1 131.93,158.13 pfet
X$56 VDD GDRV VDD VDD sky130_fd_pr__pfet_01v8 L=20 W=30 AS=12.6 AD=12.6
+ PS=60.84 PD=60.84
* device instance $57 r0 *1 153.17,158.13 pfet
X$57 VDD GDRV VDD VDD sky130_fd_pr__pfet_01v8 L=20 W=30 AS=12.6 AD=12.6
+ PS=60.84 PD=60.84
* device instance $58 r0 *1 174.41,158.13 pfet
X$58 VDD GDRV VDD VDD sky130_fd_pr__pfet_01v8 L=20 W=30 AS=12.6 AD=12.6
+ PS=60.84 PD=60.84
* device instance $59 r0 *1 195.65,158.13 pfet
X$59 VDD GDRV VDD VDD sky130_fd_pr__pfet_01v8 L=20 W=30 AS=12.6 AD=12.6
+ PS=60.84 PD=60.84
* device instance $60 r0 *1 216.89,158.13 pfet
X$60 VDD GDRV VDD VDD sky130_fd_pr__pfet_01v8 L=20 W=30 AS=12.6 AD=12.6
+ PS=60.84 PD=60.84
* device instance $61 r0 *1 238.13,158.13 pfet
X$61 VDD GDRV VDD VDD sky130_fd_pr__pfet_01v8 L=20 W=30 AS=12.6 AD=12.6
+ PS=60.84 PD=60.84
* device instance $62 r0 *1 259.37,158.13 pfet
X$62 VDD GDRV VDD VDD sky130_fd_pr__pfet_01v8 L=20 W=30 AS=12.6 AD=12.6
+ PS=60.84 PD=60.84
* device instance $63 r0 *1 280.61,158.13 pfet
X$63 VDD GDRV VDD VDD sky130_fd_pr__pfet_01v8 L=20 W=30 AS=12.6 AD=12.6
+ PS=60.84 PD=60.84
* device instance $64 r0 *1 75.61,174.45 pfet
X$64 NG NG \$182 VDD sky130_fd_pr__pfet_01v8 L=20 W=1 AS=0.42 AD=0.42 PS=2.84
+ PD=2.84
* device instance $65 r0 *1 75.61,172.63 pfet
X$65 \$182 \$182 GDRV VDD sky130_fd_pr__pfet_01v8 L=20 W=1 AS=0.42 AD=0.42
+ PS=2.84 PD=2.84
* device instance $66 r0 *1 131.93,188.95 pfet
X$66 VDD GDRV VDD VDD sky130_fd_pr__pfet_01v8 L=20 W=30 AS=12.6 AD=12.6
+ PS=60.84 PD=60.84
* device instance $67 r0 *1 153.17,188.95 pfet
X$67 VDD GDRV VDD VDD sky130_fd_pr__pfet_01v8 L=20 W=30 AS=12.6 AD=12.6
+ PS=60.84 PD=60.84
* device instance $68 r0 *1 174.41,188.95 pfet
X$68 VDD GDRV VDD VDD sky130_fd_pr__pfet_01v8 L=20 W=30 AS=12.6 AD=12.6
+ PS=60.84 PD=60.84
* device instance $69 r0 *1 195.65,188.95 pfet
X$69 VDD GDRV VDD VDD sky130_fd_pr__pfet_01v8 L=20 W=30 AS=12.6 AD=12.6
+ PS=60.84 PD=60.84
* device instance $70 r0 *1 216.89,188.95 pfet
X$70 VDD GDRV VDD VDD sky130_fd_pr__pfet_01v8 L=20 W=30 AS=12.6 AD=12.6
+ PS=60.84 PD=60.84
* device instance $71 r0 *1 238.13,188.95 pfet
X$71 VDD GDRV VDD VDD sky130_fd_pr__pfet_01v8 L=20 W=30 AS=12.6 AD=12.6
+ PS=60.84 PD=60.84
* device instance $72 r0 *1 259.37,188.95 pfet
X$72 VDD GDRV VDD VDD sky130_fd_pr__pfet_01v8 L=20 W=30 AS=12.6 AD=12.6
+ PS=60.84 PD=60.84
* device instance $73 r0 *1 280.61,188.95 pfet
X$73 VDD GDRV VDD VDD sky130_fd_pr__pfet_01v8 L=20 W=30 AS=12.6 AD=12.6
+ PS=60.84 PD=60.84
* device instance $74 r0 *1 12.96,1.31 pnp
X$74 VSS VSS VA sky130_fd_pr__pnp_05v5_W0p68L0p68
* device instance $75 r0 *1 14.86,1.31 pnp
X$75 VSS VSS VA sky130_fd_pr__pnp_05v5_W0p68L0p68
* device instance $76 r0 *1 16.76,1.31 pnp
X$76 VSS VSS VA sky130_fd_pr__pnp_05v5_W0p68L0p68
* device instance $77 r0 *1 18.66,1.31 pnp
X$77 VSS VSS VA sky130_fd_pr__pnp_05v5_W0p68L0p68
* device instance $78 r0 *1 12.96,2.39 pnp
X$78 VSS VSS VA sky130_fd_pr__pnp_05v5_W0p68L0p68
* device instance $79 r0 *1 14.86,2.39 pnp
X$79 VSS VSS VA sky130_fd_pr__pnp_05v5_W0p68L0p68
* device instance $80 r0 *1 16.76,2.39 pnp
X$80 VSS VSS VA sky130_fd_pr__pnp_05v5_W0p68L0p68
* device instance $81 r0 *1 18.66,2.39 pnp
X$81 VSS VSS VA sky130_fd_pr__pnp_05v5_W0p68L0p68
* device instance $82 r0 *1 260.38,2.67 pnp
X$82 VSS VSS VBQ sky130_fd_pr__pnp_05v5_W3p40L3p40
* device instance $83 r0 *1 265,2.67 pnp
X$83 VSS VSS VBQ sky130_fd_pr__pnp_05v5_W3p40L3p40
* device instance $84 r0 *1 269.62,2.67 pnp
X$84 VSS VSS VBQ sky130_fd_pr__pnp_05v5_W3p40L3p40
* device instance $85 r0 *1 274.24,2.67 pnp
X$85 VSS VSS VBQ sky130_fd_pr__pnp_05v5_W3p40L3p40
* device instance $86 r0 *1 260.38,6.47 pnp
X$86 VSS VSS VBQ sky130_fd_pr__pnp_05v5_W3p40L3p40
* device instance $87 r0 *1 265,6.47 pnp
X$87 VSS VSS VBQ sky130_fd_pr__pnp_05v5_W3p40L3p40
* device instance $88 r0 *1 269.62,6.47 pnp
X$88 VSS VSS VBQ sky130_fd_pr__pnp_05v5_W3p40L3p40
* device instance $89 r0 *1 274.24,6.47 pnp
X$89 VSS VSS VBQ sky130_fd_pr__pnp_05v5_W3p40L3p40
* device instance $90 r0 *1 38.39,143.37 pnp
X$90 VSS VSS NE sky130_fd_pr__pnp_05v5_W0p68L0p68
* device instance $91 r0 *1 40.29,143.37 pnp
X$91 VSS VSS NE sky130_fd_pr__pnp_05v5_W0p68L0p68
* device instance $92 r0 *1 42.19,143.37 pnp
X$92 VSS VSS NE sky130_fd_pr__pnp_05v5_W0p68L0p68
* device instance $93 r0 *1 44.09,143.37 pnp
X$93 VSS VSS NE sky130_fd_pr__pnp_05v5_W0p68L0p68
* device instance $94 r0 *1 38.39,144.45 pnp
X$94 VSS VSS NE sky130_fd_pr__pnp_05v5_W0p68L0p68
* device instance $95 r0 *1 40.29,144.45 pnp
X$95 VSS VSS NE sky130_fd_pr__pnp_05v5_W0p68L0p68
* device instance $96 r0 *1 42.19,144.45 pnp
X$96 VSS VSS NE sky130_fd_pr__pnp_05v5_W0p68L0p68
* device instance $97 r0 *1 44.09,144.45 pnp
X$97 VSS VSS NE sky130_fd_pr__pnp_05v5_W0p68L0p68
* device instance $98 r0 *1 54.29,0.5 res_high_po
X$98 VOUT \$7 VSS sky130_fd_pr__res_high_po l=5 w=1
* device instance $99 r0 *1 60.63,0.5 res_high_po
X$99 VOUT \$8 VSS sky130_fd_pr__res_high_po l=5 w=1
* device instance $100 r0 *1 66.97,0.5 res_high_po
X$100 \$7 \$9 VSS sky130_fd_pr__res_high_po l=5 w=1
* device instance $101 r0 *1 73.31,0.5 res_high_po
X$101 \$8 \$10 VSS sky130_fd_pr__res_high_po l=5 w=1
* device instance $102 r0 *1 79.65,0.5 res_high_po
X$102 \$9 \$11 VSS sky130_fd_pr__res_high_po l=5 w=1
* device instance $103 r0 *1 85.99,0.5 res_high_po
X$103 \$10 \$12 VSS sky130_fd_pr__res_high_po l=5 w=1
* device instance $104 r0 *1 92.33,0.5 res_high_po
X$104 \$11 \$13 VSS sky130_fd_pr__res_high_po l=5 w=1
* device instance $105 r0 *1 98.67,0.5 res_high_po
X$105 \$12 \$14 VSS sky130_fd_pr__res_high_po l=5 w=1
* device instance $106 r0 *1 105.01,0.5 res_high_po
X$106 \$13 \$15 VSS sky130_fd_pr__res_high_po l=5 w=1
* device instance $107 r0 *1 111.35,0.5 res_high_po
X$107 \$14 \$16 VSS sky130_fd_pr__res_high_po l=5 w=1
* device instance $108 r0 *1 54.29,3.3 res_high_po
X$108 \$21 \$36 VSS sky130_fd_pr__res_high_po l=5 w=1
* device instance $109 r0 *1 54.29,1.9 res_high_po
X$109 \$22 \$23 VSS sky130_fd_pr__res_high_po l=5 w=1
* device instance $110 r0 *1 60.63,1.9 res_high_po
X$110 \$21 \$24 VSS sky130_fd_pr__res_high_po l=5 w=1
* device instance $111 r0 *1 60.63,3.3 res_high_po
X$111 \$22 \$37 VSS sky130_fd_pr__res_high_po l=5 w=1
* device instance $112 r0 *1 66.97,1.9 res_high_po
X$112 \$23 \$25 VSS sky130_fd_pr__res_high_po l=5 w=1
* device instance $113 r0 *1 66.97,3.3 res_high_po
X$113 \$36 \$38 VSS sky130_fd_pr__res_high_po l=5 w=1
* device instance $114 r0 *1 73.31,1.9 res_high_po
X$114 \$24 \$26 VSS sky130_fd_pr__res_high_po l=5 w=1
* device instance $115 r0 *1 73.31,3.3 res_high_po
X$115 \$37 \$39 VSS sky130_fd_pr__res_high_po l=5 w=1
* device instance $116 r0 *1 79.65,1.9 res_high_po
X$116 \$25 \$27 VSS sky130_fd_pr__res_high_po l=5 w=1
* device instance $117 r0 *1 79.65,3.3 res_high_po
X$117 \$38 \$40 VSS sky130_fd_pr__res_high_po l=5 w=1
* device instance $118 r0 *1 85.99,3.3 res_high_po
X$118 \$39 \$41 VSS sky130_fd_pr__res_high_po l=5 w=1
* device instance $119 r0 *1 85.99,1.9 res_high_po
X$119 \$26 \$28 VSS sky130_fd_pr__res_high_po l=5 w=1
* device instance $120 r0 *1 92.33,1.9 res_high_po
X$120 \$27 \$29 VSS sky130_fd_pr__res_high_po l=5 w=1
* device instance $121 r0 *1 92.33,3.3 res_high_po
X$121 \$40 \$42 VSS sky130_fd_pr__res_high_po l=5 w=1
* device instance $122 r0 *1 98.67,3.3 res_high_po
X$122 \$41 \$43 VSS sky130_fd_pr__res_high_po l=5 w=1
* device instance $123 r0 *1 98.67,1.9 res_high_po
X$123 \$28 \$30 VSS sky130_fd_pr__res_high_po l=5 w=1
* device instance $124 r0 *1 105.01,3.3 res_high_po
X$124 \$42 \$44 VSS sky130_fd_pr__res_high_po l=5 w=1
* device instance $125 r0 *1 105.01,1.9 res_high_po
X$125 \$29 \$16 VSS sky130_fd_pr__res_high_po l=5 w=1
* device instance $126 r0 *1 111.35,1.9 res_high_po
X$126 \$30 \$15 VSS sky130_fd_pr__res_high_po l=5 w=1
* device instance $127 r0 *1 111.35,3.3 res_high_po
X$127 \$43 \$45 VSS sky130_fd_pr__res_high_po l=5 w=1
* device instance $128 r0 *1 54.29,4.7 res_high_po
X$128 \$47 \$48 VSS sky130_fd_pr__res_high_po l=5 w=1
* device instance $129 r0 *1 60.63,4.7 res_high_po
X$129 \$46 \$49 VSS sky130_fd_pr__res_high_po l=5 w=1
* device instance $130 r0 *1 66.97,4.7 res_high_po
X$130 \$48 \$50 VSS sky130_fd_pr__res_high_po l=5 w=1
* device instance $131 r0 *1 73.31,4.7 res_high_po
X$131 \$49 \$51 VSS sky130_fd_pr__res_high_po l=5 w=1
* device instance $132 r0 *1 79.65,4.7 res_high_po
X$132 \$50 \$52 VSS sky130_fd_pr__res_high_po l=5 w=1
* device instance $133 r0 *1 85.99,4.7 res_high_po
X$133 \$51 \$53 VSS sky130_fd_pr__res_high_po l=5 w=1
* device instance $134 r0 *1 92.33,4.7 res_high_po
X$134 \$52 \$54 VSS sky130_fd_pr__res_high_po l=5 w=1
* device instance $135 r0 *1 98.67,4.7 res_high_po
X$135 \$53 \$55 VSS sky130_fd_pr__res_high_po l=5 w=1
* device instance $136 r0 *1 105.01,4.7 res_high_po
X$136 \$54 \$45 VSS sky130_fd_pr__res_high_po l=5 w=1
* device instance $137 r0 *1 111.35,4.7 res_high_po
X$137 \$55 \$44 VSS sky130_fd_pr__res_high_po l=5 w=1
* device instance $138 r0 *1 54.29,6.1 res_high_po
X$138 \$46 \$56 VSS sky130_fd_pr__res_high_po l=5 w=1
* device instance $139 r0 *1 60.63,6.1 res_high_po
X$139 \$47 \$57 VSS sky130_fd_pr__res_high_po l=5 w=1
* device instance $140 r0 *1 66.97,6.1 res_high_po
X$140 \$56 \$58 VSS sky130_fd_pr__res_high_po l=5 w=1
* device instance $141 r0 *1 73.31,6.1 res_high_po
X$141 \$57 \$59 VSS sky130_fd_pr__res_high_po l=5 w=1
* device instance $142 r0 *1 79.65,6.1 res_high_po
X$142 \$58 \$60 VSS sky130_fd_pr__res_high_po l=5 w=1
* device instance $143 r0 *1 85.99,6.1 res_high_po
X$143 \$59 \$61 VSS sky130_fd_pr__res_high_po l=5 w=1
* device instance $144 r0 *1 92.33,6.1 res_high_po
X$144 \$60 \$62 VSS sky130_fd_pr__res_high_po l=5 w=1
* device instance $145 r0 *1 98.67,6.1 res_high_po
X$145 \$61 \$63 VSS sky130_fd_pr__res_high_po l=5 w=1
* device instance $146 r0 *1 105.01,6.1 res_high_po
X$146 \$62 \$64 VSS sky130_fd_pr__res_high_po l=5 w=1
* device instance $147 r0 *1 111.35,6.1 res_high_po
X$147 \$63 \$65 VSS sky130_fd_pr__res_high_po l=5 w=1
* device instance $148 r0 *1 54.29,7.5 res_high_po
X$148 \$67 \$68 VSS sky130_fd_pr__res_high_po l=5 w=1
* device instance $149 r0 *1 60.63,7.5 res_high_po
X$149 \$66 \$69 VSS sky130_fd_pr__res_high_po l=5 w=1
* device instance $150 r0 *1 66.97,7.5 res_high_po
X$150 \$68 \$70 VSS sky130_fd_pr__res_high_po l=5 w=1
* device instance $151 r0 *1 73.31,7.5 res_high_po
X$151 \$69 \$71 VSS sky130_fd_pr__res_high_po l=5 w=1
* device instance $152 r0 *1 79.65,7.5 res_high_po
X$152 \$70 \$72 VSS sky130_fd_pr__res_high_po l=5 w=1
* device instance $153 r0 *1 85.99,7.5 res_high_po
X$153 \$71 \$73 VSS sky130_fd_pr__res_high_po l=5 w=1
* device instance $154 r0 *1 92.33,7.5 res_high_po
X$154 \$72 \$74 VSS sky130_fd_pr__res_high_po l=5 w=1
* device instance $155 r0 *1 98.67,7.5 res_high_po
X$155 \$73 \$75 VSS sky130_fd_pr__res_high_po l=5 w=1
* device instance $156 r0 *1 105.01,7.5 res_high_po
X$156 \$74 \$65 VSS sky130_fd_pr__res_high_po l=5 w=1
* device instance $157 r0 *1 111.35,7.5 res_high_po
X$157 \$75 \$64 VSS sky130_fd_pr__res_high_po l=5 w=1
* device instance $158 r0 *1 54.29,8.9 res_high_po
X$158 \$66 \$78 VSS sky130_fd_pr__res_high_po l=5 w=1
* device instance $159 r0 *1 60.63,8.9 res_high_po
X$159 \$67 \$79 VSS sky130_fd_pr__res_high_po l=5 w=1
* device instance $160 r0 *1 66.97,8.9 res_high_po
X$160 \$78 \$80 VSS sky130_fd_pr__res_high_po l=5 w=1
* device instance $161 r0 *1 73.31,8.9 res_high_po
X$161 \$79 \$81 VSS sky130_fd_pr__res_high_po l=5 w=1
* device instance $162 r0 *1 79.65,8.9 res_high_po
X$162 \$80 \$82 VSS sky130_fd_pr__res_high_po l=5 w=1
* device instance $163 r0 *1 85.99,8.9 res_high_po
X$163 \$81 \$83 VSS sky130_fd_pr__res_high_po l=5 w=1
* device instance $164 r0 *1 92.33,8.9 res_high_po
X$164 \$82 \$84 VSS sky130_fd_pr__res_high_po l=5 w=1
* device instance $165 r0 *1 98.67,8.9 res_high_po
X$165 \$83 \$85 VSS sky130_fd_pr__res_high_po l=5 w=1
* device instance $166 r0 *1 105.01,8.9 res_high_po
X$166 \$84 \$86 VSS sky130_fd_pr__res_high_po l=5 w=1
* device instance $167 r0 *1 111.35,8.9 res_high_po
X$167 \$85 \$99 VSS sky130_fd_pr__res_high_po l=5 w=1
* device instance $168 r0 *1 134.62,8.9 res_high_po
X$168 \$2 \$89 VSS sky130_fd_pr__res_high_po l=0.5 w=1
* device instance $169 r0 *1 136.46,8.9 res_high_po
X$169 \$168 \$90 VSS sky130_fd_pr__res_high_po l=0.5 w=1
* device instance $170 r0 *1 138.3,8.9 res_high_po
X$170 \$89 \$91 VSS sky130_fd_pr__res_high_po l=0.5 w=1
* device instance $171 r0 *1 140.14,8.9 res_high_po
X$171 \$90 \$92 VSS sky130_fd_pr__res_high_po l=0.5 w=1
* device instance $172 r0 *1 141.98,8.9 res_high_po
X$172 \$91 \$93 VSS sky130_fd_pr__res_high_po l=0.5 w=1
* device instance $173 r0 *1 143.82,8.9 res_high_po
X$173 \$92 \$94 VSS sky130_fd_pr__res_high_po l=0.5 w=1
* device instance $174 r0 *1 145.66,8.9 res_high_po
X$174 \$93 \$95 VSS sky130_fd_pr__res_high_po l=0.5 w=1
* device instance $175 r0 *1 147.5,8.9 res_high_po
X$175 \$94 \$96 VSS sky130_fd_pr__res_high_po l=0.5 w=1
* device instance $176 r0 *1 149.34,8.9 res_high_po
X$176 \$95 \$97 VSS sky130_fd_pr__res_high_po l=0.5 w=1
* device instance $177 r0 *1 151.18,8.9 res_high_po
X$177 \$96 \$101 VSS sky130_fd_pr__res_high_po l=0.5 w=1
* device instance $178 r0 *1 54.29,10.3 res_high_po
X$178 \$102 \$103 VSS sky130_fd_pr__res_high_po l=5 w=1
* device instance $179 r0 *1 54.29,11.7 res_high_po
X$179 \$98 \$120 VSS sky130_fd_pr__res_high_po l=5 w=1
* device instance $180 r0 *1 60.63,10.3 res_high_po
X$180 \$98 \$104 VSS sky130_fd_pr__res_high_po l=5 w=1
* device instance $181 r0 *1 60.63,11.7 res_high_po
X$181 \$102 \$121 VSS sky130_fd_pr__res_high_po l=5 w=1
* device instance $182 r0 *1 66.97,10.3 res_high_po
X$182 \$103 \$105 VSS sky130_fd_pr__res_high_po l=5 w=1
* device instance $183 r0 *1 66.97,11.7 res_high_po
X$183 \$120 \$122 VSS sky130_fd_pr__res_high_po l=5 w=1
* device instance $184 r0 *1 73.31,11.7 res_high_po
X$184 \$121 \$123 VSS sky130_fd_pr__res_high_po l=5 w=1
* device instance $185 r0 *1 73.31,10.3 res_high_po
X$185 \$104 \$106 VSS sky130_fd_pr__res_high_po l=5 w=1
* device instance $186 r0 *1 79.65,10.3 res_high_po
X$186 \$105 \$107 VSS sky130_fd_pr__res_high_po l=5 w=1
* device instance $187 r0 *1 79.65,11.7 res_high_po
X$187 \$122 \$124 VSS sky130_fd_pr__res_high_po l=5 w=1
* device instance $188 r0 *1 85.99,11.7 res_high_po
X$188 \$123 \$125 VSS sky130_fd_pr__res_high_po l=5 w=1
* device instance $189 r0 *1 85.99,10.3 res_high_po
X$189 \$106 \$108 VSS sky130_fd_pr__res_high_po l=5 w=1
* device instance $190 r0 *1 92.33,11.7 res_high_po
X$190 \$124 \$126 VSS sky130_fd_pr__res_high_po l=5 w=1
* device instance $191 r0 *1 92.33,10.3 res_high_po
X$191 \$107 \$109 VSS sky130_fd_pr__res_high_po l=5 w=1
* device instance $192 r0 *1 98.67,11.7 res_high_po
X$192 \$125 \$127 VSS sky130_fd_pr__res_high_po l=5 w=1
* device instance $193 r0 *1 98.67,10.3 res_high_po
X$193 \$108 \$110 VSS sky130_fd_pr__res_high_po l=5 w=1
* device instance $194 r0 *1 105.01,10.3 res_high_po
X$194 \$109 \$99 VSS sky130_fd_pr__res_high_po l=5 w=1
* device instance $195 r0 *1 105.01,11.7 res_high_po
X$195 \$126 \$128 VSS sky130_fd_pr__res_high_po l=5 w=1
* device instance $196 r0 *1 111.35,10.3 res_high_po
X$196 \$110 \$86 VSS sky130_fd_pr__res_high_po l=5 w=1
* device instance $197 r0 *1 111.35,11.7 res_high_po
X$197 \$127 \$129 VSS sky130_fd_pr__res_high_po l=5 w=1
* device instance $198 r0 *1 134.62,11.7 res_high_po
X$198 \$100 \$130 VSS sky130_fd_pr__res_high_po l=0.5 w=1
* device instance $199 r0 *1 134.62,10.3 res_high_po
X$199 \$111 \$112 VSS sky130_fd_pr__res_high_po l=0.5 w=1
* device instance $200 r0 *1 136.46,10.3 res_high_po
X$200 \$100 \$113 VSS sky130_fd_pr__res_high_po l=0.5 w=1
* device instance $201 r0 *1 136.46,11.7 res_high_po
X$201 \$111 \$131 VSS sky130_fd_pr__res_high_po l=0.5 w=1
* device instance $202 r0 *1 138.3,10.3 res_high_po
X$202 \$112 \$114 VSS sky130_fd_pr__res_high_po l=0.5 w=1
* device instance $203 r0 *1 138.3,11.7 res_high_po
X$203 \$130 \$132 VSS sky130_fd_pr__res_high_po l=0.5 w=1
* device instance $204 r0 *1 140.14,10.3 res_high_po
X$204 \$113 \$115 VSS sky130_fd_pr__res_high_po l=0.5 w=1
* device instance $205 r0 *1 140.14,11.7 res_high_po
X$205 \$131 \$133 VSS sky130_fd_pr__res_high_po l=0.5 w=1
* device instance $206 r0 *1 141.98,11.7 res_high_po
X$206 \$132 \$134 VSS sky130_fd_pr__res_high_po l=0.5 w=1
* device instance $207 r0 *1 141.98,10.3 res_high_po
X$207 \$114 \$116 VSS sky130_fd_pr__res_high_po l=0.5 w=1
* device instance $208 r0 *1 143.82,11.7 res_high_po
X$208 \$133 \$135 VSS sky130_fd_pr__res_high_po l=0.5 w=1
* device instance $209 r0 *1 143.82,10.3 res_high_po
X$209 \$115 \$117 VSS sky130_fd_pr__res_high_po l=0.5 w=1
* device instance $210 r0 *1 145.66,10.3 res_high_po
X$210 \$116 \$118 VSS sky130_fd_pr__res_high_po l=0.5 w=1
* device instance $211 r0 *1 145.66,11.7 res_high_po
X$211 \$134 \$136 VSS sky130_fd_pr__res_high_po l=0.5 w=1
* device instance $212 r0 *1 147.5,11.7 res_high_po
X$212 \$135 \$137 VSS sky130_fd_pr__res_high_po l=0.5 w=1
* device instance $213 r0 *1 147.5,10.3 res_high_po
X$213 \$117 \$119 VSS sky130_fd_pr__res_high_po l=0.5 w=1
* device instance $214 r0 *1 149.34,11.7 res_high_po
X$214 \$136 \$138 VSS sky130_fd_pr__res_high_po l=0.5 w=1
* device instance $215 r0 *1 149.34,10.3 res_high_po
X$215 \$118 \$101 VSS sky130_fd_pr__res_high_po l=0.5 w=1
* device instance $216 r0 *1 151.18,11.7 res_high_po
X$216 \$137 \$139 VSS sky130_fd_pr__res_high_po l=0.5 w=1
* device instance $217 r0 *1 151.18,10.3 res_high_po
X$217 \$119 \$97 VSS sky130_fd_pr__res_high_po l=0.5 w=1
* device instance $218 r0 *1 66.97,13.1 res_high_po
X$218 \$168 \$142 VSS sky130_fd_pr__res_high_po l=5 w=1
* device instance $219 r0 *1 73.31,13.1 res_high_po
X$219 \$2 \$143 VSS sky130_fd_pr__res_high_po l=5 w=1
* device instance $220 r0 *1 79.65,13.1 res_high_po
X$220 \$142 \$144 VSS sky130_fd_pr__res_high_po l=5 w=1
* device instance $221 r0 *1 85.99,13.1 res_high_po
X$221 \$143 \$145 VSS sky130_fd_pr__res_high_po l=5 w=1
* device instance $222 r0 *1 92.33,13.1 res_high_po
X$222 \$144 \$146 VSS sky130_fd_pr__res_high_po l=5 w=1
* device instance $223 r0 *1 98.67,13.1 res_high_po
X$223 \$145 \$147 VSS sky130_fd_pr__res_high_po l=5 w=1
* device instance $224 r0 *1 105.01,13.1 res_high_po
X$224 \$146 \$129 VSS sky130_fd_pr__res_high_po l=5 w=1
* device instance $225 r0 *1 111.35,13.1 res_high_po
X$225 \$147 \$128 VSS sky130_fd_pr__res_high_po l=5 w=1
* device instance $226 r0 *1 134.62,13.1 res_high_po
X$226 VB \$150 VSS sky130_fd_pr__res_high_po l=0.5 w=1
* device instance $227 r0 *1 136.46,13.1 res_high_po
X$227 VA \$151 VSS sky130_fd_pr__res_high_po l=0.5 w=1
* device instance $228 r0 *1 138.3,13.1 res_high_po
X$228 \$150 \$152 VSS sky130_fd_pr__res_high_po l=0.5 w=1
* device instance $229 r0 *1 140.14,13.1 res_high_po
X$229 \$151 \$153 VSS sky130_fd_pr__res_high_po l=0.5 w=1
* device instance $230 r0 *1 141.98,13.1 res_high_po
X$230 \$152 \$154 VSS sky130_fd_pr__res_high_po l=0.5 w=1
* device instance $231 r0 *1 143.82,13.1 res_high_po
X$231 \$153 \$155 VSS sky130_fd_pr__res_high_po l=0.5 w=1
* device instance $232 r0 *1 145.66,13.1 res_high_po
X$232 \$154 \$156 VSS sky130_fd_pr__res_high_po l=0.5 w=1
* device instance $233 r0 *1 147.5,13.1 res_high_po
X$233 \$155 \$157 VSS sky130_fd_pr__res_high_po l=0.5 w=1
* device instance $234 r0 *1 149.34,13.1 res_high_po
X$234 \$156 \$139 VSS sky130_fd_pr__res_high_po l=0.5 w=1
* device instance $235 r0 *1 151.18,13.1 res_high_po
X$235 \$157 \$138 VSS sky130_fd_pr__res_high_po l=0.5 w=1
* device instance $236 r0 *1 183.45,13.1 res_high_po
X$236 VB \$160 VSS sky130_fd_pr__res_high_po l=5 w=1
* device instance $237 r0 *1 189.79,13.1 res_high_po
X$237 \$160 \$161 VSS sky130_fd_pr__res_high_po l=5 w=1
* device instance $238 r0 *1 196.13,13.1 res_high_po
X$238 \$161 \$162 VSS sky130_fd_pr__res_high_po l=5 w=1
* device instance $239 r0 *1 202.47,13.1 res_high_po
X$239 \$162 \$163 VSS sky130_fd_pr__res_high_po l=5 w=1
* device instance $240 r0 *1 208.81,13.1 res_high_po
X$240 \$163 \$164 VSS sky130_fd_pr__res_high_po l=5 w=1
* device instance $241 r0 *1 215.15,13.1 res_high_po
X$241 \$164 \$165 VSS sky130_fd_pr__res_high_po l=5 w=1
* device instance $242 r0 *1 221.49,13.1 res_high_po
X$242 \$165 VBQ VSS sky130_fd_pr__res_high_po l=5 w=1
.ENDS bandgap_core_routed
