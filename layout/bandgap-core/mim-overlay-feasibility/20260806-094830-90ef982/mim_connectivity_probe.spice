* extracted by klt extract --deck sky130

* cell mim_connectivity_probe
.SUBCKT mim_connectivity_probe
* device instance $1 r0 *1 10,7.5 sky130_fd_pr__model__cap_mim
C$1 \$3 \$4 3.6226e-13 sky130_fd_pr__model__cap_mim
.ENDS mim_connectivity_probe
