* extracted by klt extract --deck sky130

* cell bandgap_core_routed
* pin D1
* pin D2
* pin GDRV
* pin PN
* pin TAIL
* pin VA
* pin VB
* pin VBQ
* pin VDD
* pin VOUT
* pin VSS
.SUBCKT bandgap_core_routed D1 D2 GDRV PN TAIL VA VB VBQ VDD VOUT VSS
* device instance $1 r0 *1 233.14,52.67 nfet
M$1 VSS D1 D1 VSS nfet L=20U W=8U AS=3.36P AD=3.36P PS=16.84U PD=16.84U
* device instance $2 r0 *1 254.38,52.67 nfet
M$2 VSS D2 D2 VSS nfet L=20U W=8U AS=3.36P AD=3.36P PS=16.84U PD=16.84U
* device instance $3 r0 *1 275.62,52.67 nfet
M$3 VSS D1 D1 VSS nfet L=20U W=8U AS=3.36P AD=3.36P PS=16.84U PD=16.84U
* device instance $4 r0 *1 296.86,52.67 nfet
M$4 VSS D2 D2 VSS nfet L=20U W=8U AS=3.36P AD=3.36P PS=16.84U PD=16.84U
* device instance $5 r0 *1 233.14,61.49 nfet
M$5 VSS D2 D2 VSS nfet L=20U W=8U AS=3.36P AD=3.36P PS=16.84U PD=16.84U
* device instance $6 r0 *1 254.38,61.49 nfet
M$6 VSS D1 D1 VSS nfet L=20U W=8U AS=3.36P AD=3.36P PS=16.84U PD=16.84U
* device instance $7 r0 *1 275.62,61.49 nfet
M$7 VSS D2 D2 VSS nfet L=20U W=8U AS=3.36P AD=3.36P PS=16.84U PD=16.84U
* device instance $8 r0 *1 296.86,61.49 nfet
M$8 VSS D1 D1 VSS nfet L=20U W=8U AS=3.36P AD=3.36P PS=16.84U PD=16.84U
* device instance $9 r0 *1 216.07,105.9 nfet
M$9 VSS D2 PN VSS nfet L=20U W=8U AS=3.36P AD=3.36P PS=16.84U PD=16.84U
* device instance $10 r0 *1 237.31,105.9 nfet
M$10 VSS D1 GDRV VSS nfet L=20U W=8U AS=3.36P AD=3.36P PS=16.84U PD=16.84U
* device instance $11 r0 *1 258.55,105.9 nfet
M$11 VSS D2 PN VSS nfet L=20U W=8U AS=3.36P AD=3.36P PS=16.84U PD=16.84U
* device instance $12 r0 *1 279.79,105.9 nfet
M$12 VSS D1 GDRV VSS nfet L=20U W=8U AS=3.36P AD=3.36P PS=16.84U PD=16.84U
* device instance $13 r0 *1 216.07,114.72 nfet
M$13 VSS D1 GDRV VSS nfet L=20U W=8U AS=3.36P AD=3.36P PS=16.84U PD=16.84U
* device instance $14 r0 *1 237.31,114.72 nfet
M$14 VSS D2 PN VSS nfet L=20U W=8U AS=3.36P AD=3.36P PS=16.84U PD=16.84U
* device instance $15 r0 *1 258.55,114.72 nfet
M$15 VSS D1 GDRV VSS nfet L=20U W=8U AS=3.36P AD=3.36P PS=16.84U PD=16.84U
* device instance $16 r0 *1 279.79,114.72 nfet
M$16 VSS D2 PN VSS nfet L=20U W=8U AS=3.36P AD=3.36P PS=16.84U PD=16.84U
* device instance $17 r0 *1 30.71,46.67 pfet
M$17 D2 VA TAIL VDD pfet L=10U W=20U AS=8.4P AD=8.4P PS=40.84U PD=40.84U
* device instance $18 r0 *1 41.95,46.67 pfet
M$18 D1 VB TAIL VDD pfet L=10U W=20U AS=8.4P AD=8.4P PS=40.84U PD=40.84U
* device instance $19 r0 *1 53.19,46.67 pfet
M$19 D2 VA TAIL VDD pfet L=10U W=20U AS=8.4P AD=8.4P PS=40.84U PD=40.84U
* device instance $20 r0 *1 64.43,46.67 pfet
M$20 D1 VB TAIL VDD pfet L=10U W=20U AS=8.4P AD=8.4P PS=40.84U PD=40.84U
* device instance $21 r0 *1 75.67,46.67 pfet
M$21 D2 VA TAIL VDD pfet L=10U W=20U AS=8.4P AD=8.4P PS=40.84U PD=40.84U
* device instance $22 r0 *1 86.91,46.67 pfet
M$22 D1 VB TAIL VDD pfet L=10U W=20U AS=8.4P AD=8.4P PS=40.84U PD=40.84U
* device instance $23 r0 *1 98.15,46.67 pfet
M$23 D2 VA TAIL VDD pfet L=10U W=20U AS=8.4P AD=8.4P PS=40.84U PD=40.84U
* device instance $24 r0 *1 109.39,46.67 pfet
M$24 D1 VB TAIL VDD pfet L=10U W=20U AS=8.4P AD=8.4P PS=40.84U PD=40.84U
* device instance $25 r0 *1 120.63,46.67 pfet
M$25 D2 VA TAIL VDD pfet L=10U W=20U AS=8.4P AD=8.4P PS=40.84U PD=40.84U
* device instance $26 r0 *1 131.87,46.67 pfet
M$26 D1 VB TAIL VDD pfet L=10U W=20U AS=8.4P AD=8.4P PS=40.84U PD=40.84U
* device instance $27 r0 *1 143.11,46.67 pfet
M$27 D2 VA TAIL VDD pfet L=10U W=20U AS=8.4P AD=8.4P PS=40.84U PD=40.84U
* device instance $28 r0 *1 154.35,46.67 pfet
M$28 D1 VB TAIL VDD pfet L=10U W=20U AS=8.4P AD=8.4P PS=40.84U PD=40.84U
* device instance $29 r0 *1 165.59,46.67 pfet
M$29 D2 VA TAIL VDD pfet L=10U W=20U AS=8.4P AD=8.4P PS=40.84U PD=40.84U
* device instance $30 r0 *1 176.83,46.67 pfet
M$30 D1 VB TAIL VDD pfet L=10U W=20U AS=8.4P AD=8.4P PS=40.84U PD=40.84U
* device instance $31 r0 *1 188.07,46.67 pfet
M$31 D2 VA TAIL VDD pfet L=10U W=20U AS=8.4P AD=8.4P PS=40.84U PD=40.84U
* device instance $32 r0 *1 199.31,46.67 pfet
M$32 D1 VB TAIL VDD pfet L=10U W=20U AS=8.4P AD=8.4P PS=40.84U PD=40.84U
* device instance $33 r0 *1 2.49,61.49 pfet
M$33 TAIL GDRV VDD VDD pfet L=2U W=8U AS=3.36P AD=3.36P PS=16.84U PD=16.84U
* device instance $34 r0 *1 2.49,52.67 pfet
M$34 VOUT GDRV VDD VDD pfet L=2U W=8U AS=3.36P AD=3.36P PS=16.84U PD=16.84U
* device instance $35 r0 *1 5.73,61.49 pfet
M$35 VOUT GDRV VDD VDD pfet L=2U W=8U AS=3.36P AD=3.36P PS=16.84U PD=16.84U
* device instance $36 r0 *1 5.73,52.67 pfet
M$36 TAIL GDRV VDD VDD pfet L=2U W=8U AS=3.36P AD=3.36P PS=16.84U PD=16.84U
* device instance $37 r0 *1 30.71,67.49 pfet
M$37 D1 VB TAIL VDD pfet L=10U W=20U AS=8.4P AD=8.4P PS=40.84U PD=40.84U
* device instance $38 r0 *1 41.95,67.49 pfet
M$38 D2 VA TAIL VDD pfet L=10U W=20U AS=8.4P AD=8.4P PS=40.84U PD=40.84U
* device instance $39 r0 *1 53.19,67.49 pfet
M$39 D1 VB TAIL VDD pfet L=10U W=20U AS=8.4P AD=8.4P PS=40.84U PD=40.84U
* device instance $40 r0 *1 64.43,67.49 pfet
M$40 D2 VA TAIL VDD pfet L=10U W=20U AS=8.4P AD=8.4P PS=40.84U PD=40.84U
* device instance $41 r0 *1 75.67,67.49 pfet
M$41 D1 VB TAIL VDD pfet L=10U W=20U AS=8.4P AD=8.4P PS=40.84U PD=40.84U
* device instance $42 r0 *1 86.91,67.49 pfet
M$42 D2 VA TAIL VDD pfet L=10U W=20U AS=8.4P AD=8.4P PS=40.84U PD=40.84U
* device instance $43 r0 *1 98.15,67.49 pfet
M$43 D1 VB TAIL VDD pfet L=10U W=20U AS=8.4P AD=8.4P PS=40.84U PD=40.84U
* device instance $44 r0 *1 109.39,67.49 pfet
M$44 D2 VA TAIL VDD pfet L=10U W=20U AS=8.4P AD=8.4P PS=40.84U PD=40.84U
* device instance $45 r0 *1 120.63,67.49 pfet
M$45 D1 VB TAIL VDD pfet L=10U W=20U AS=8.4P AD=8.4P PS=40.84U PD=40.84U
* device instance $46 r0 *1 131.87,67.49 pfet
M$46 D2 VA TAIL VDD pfet L=10U W=20U AS=8.4P AD=8.4P PS=40.84U PD=40.84U
* device instance $47 r0 *1 143.11,67.49 pfet
M$47 D1 VB TAIL VDD pfet L=10U W=20U AS=8.4P AD=8.4P PS=40.84U PD=40.84U
* device instance $48 r0 *1 154.35,67.49 pfet
M$48 D2 VA TAIL VDD pfet L=10U W=20U AS=8.4P AD=8.4P PS=40.84U PD=40.84U
* device instance $49 r0 *1 165.59,67.49 pfet
M$49 D1 VB TAIL VDD pfet L=10U W=20U AS=8.4P AD=8.4P PS=40.84U PD=40.84U
* device instance $50 r0 *1 176.83,67.49 pfet
M$50 D2 VA TAIL VDD pfet L=10U W=20U AS=8.4P AD=8.4P PS=40.84U PD=40.84U
* device instance $51 r0 *1 188.07,67.49 pfet
M$51 D1 VB TAIL VDD pfet L=10U W=20U AS=8.4P AD=8.4P PS=40.84U PD=40.84U
* device instance $52 r0 *1 199.31,67.49 pfet
M$52 D2 VA TAIL VDD pfet L=10U W=20U AS=8.4P AD=8.4P PS=40.84U PD=40.84U
* device instance $53 r0 *1 28.56,106.9 pfet
M$53 PN PN VDD VDD pfet L=20U W=6U AS=2.52P AD=2.52P PS=12.84U PD=12.84U
* device instance $54 r0 *1 28.56,113.72 pfet
M$54 GDRV PN VDD VDD pfet L=20U W=6U AS=2.52P AD=2.52P PS=12.84U PD=12.84U
* device instance $55 r0 *1 49.8,113.72 pfet
M$55 PN PN VDD VDD pfet L=20U W=6U AS=2.52P AD=2.52P PS=12.84U PD=12.84U
* device instance $56 r0 *1 49.8,106.9 pfet
M$56 GDRV PN VDD VDD pfet L=20U W=6U AS=2.52P AD=2.52P PS=12.84U PD=12.84U
* device instance $57 r0 *1 71.04,106.9 pfet
M$57 PN PN VDD VDD pfet L=20U W=6U AS=2.52P AD=2.52P PS=12.84U PD=12.84U
* device instance $58 r0 *1 71.04,113.72 pfet
M$58 GDRV PN VDD VDD pfet L=20U W=6U AS=2.52P AD=2.52P PS=12.84U PD=12.84U
* device instance $59 r0 *1 79.76,158.13 pfet
M$59 VDD GDRV VDD VDD pfet L=20U W=30U AS=12.6P AD=12.6P PS=60.84U PD=60.84U
* device instance $60 r0 *1 92.28,106.9 pfet
M$60 GDRV PN VDD VDD pfet L=20U W=6U AS=2.52P AD=2.52P PS=12.84U PD=12.84U
* device instance $61 r0 *1 92.28,113.72 pfet
M$61 PN PN VDD VDD pfet L=20U W=6U AS=2.52P AD=2.52P PS=12.84U PD=12.84U
* device instance $62 r0 *1 101,158.13 pfet
M$62 VDD GDRV VDD VDD pfet L=20U W=30U AS=12.6P AD=12.6P PS=60.84U PD=60.84U
* device instance $63 r0 *1 113.52,106.9 pfet
M$63 PN PN VDD VDD pfet L=20U W=6U AS=2.52P AD=2.52P PS=12.84U PD=12.84U
* device instance $64 r0 *1 113.52,113.72 pfet
M$64 GDRV PN VDD VDD pfet L=20U W=6U AS=2.52P AD=2.52P PS=12.84U PD=12.84U
* device instance $65 r0 *1 122.24,158.13 pfet
M$65 VDD GDRV VDD VDD pfet L=20U W=30U AS=12.6P AD=12.6P PS=60.84U PD=60.84U
* device instance $66 r0 *1 134.76,106.9 pfet
M$66 GDRV PN VDD VDD pfet L=20U W=6U AS=2.52P AD=2.52P PS=12.84U PD=12.84U
* device instance $67 r0 *1 134.76,113.72 pfet
M$67 PN PN VDD VDD pfet L=20U W=6U AS=2.52P AD=2.52P PS=12.84U PD=12.84U
* device instance $68 r0 *1 143.48,158.13 pfet
M$68 VDD GDRV VDD VDD pfet L=20U W=30U AS=12.6P AD=12.6P PS=60.84U PD=60.84U
* device instance $69 r0 *1 156,106.9 pfet
M$69 PN PN VDD VDD pfet L=20U W=6U AS=2.52P AD=2.52P PS=12.84U PD=12.84U
* device instance $70 r0 *1 156,113.72 pfet
M$70 GDRV PN VDD VDD pfet L=20U W=6U AS=2.52P AD=2.52P PS=12.84U PD=12.84U
* device instance $71 r0 *1 164.72,158.13 pfet
M$71 VDD GDRV VDD VDD pfet L=20U W=30U AS=12.6P AD=12.6P PS=60.84U PD=60.84U
* device instance $72 r0 *1 177.24,106.9 pfet
M$72 GDRV PN VDD VDD pfet L=20U W=6U AS=2.52P AD=2.52P PS=12.84U PD=12.84U
* device instance $73 r0 *1 177.24,113.72 pfet
M$73 PN PN VDD VDD pfet L=20U W=6U AS=2.52P AD=2.52P PS=12.84U PD=12.84U
* device instance $74 r0 *1 185.96,158.13 pfet
M$74 VDD GDRV VDD VDD pfet L=20U W=30U AS=12.6P AD=12.6P PS=60.84U PD=60.84U
* device instance $75 r0 *1 207.2,158.13 pfet
M$75 VDD GDRV VDD VDD pfet L=20U W=30U AS=12.6P AD=12.6P PS=60.84U PD=60.84U
* device instance $76 r0 *1 228.44,158.13 pfet
M$76 VDD GDRV VDD VDD pfet L=20U W=30U AS=12.6P AD=12.6P PS=60.84U PD=60.84U
* device instance $77 r0 *1 79.76,188.95 pfet
M$77 VDD GDRV VDD VDD pfet L=20U W=30U AS=12.6P AD=12.6P PS=60.84U PD=60.84U
* device instance $78 r0 *1 101,188.95 pfet
M$78 VDD GDRV VDD VDD pfet L=20U W=30U AS=12.6P AD=12.6P PS=60.84U PD=60.84U
* device instance $79 r0 *1 122.24,188.95 pfet
M$79 VDD GDRV VDD VDD pfet L=20U W=30U AS=12.6P AD=12.6P PS=60.84U PD=60.84U
* device instance $80 r0 *1 143.48,188.95 pfet
M$80 VDD GDRV VDD VDD pfet L=20U W=30U AS=12.6P AD=12.6P PS=60.84U PD=60.84U
* device instance $81 r0 *1 164.72,188.95 pfet
M$81 VDD GDRV VDD VDD pfet L=20U W=30U AS=12.6P AD=12.6P PS=60.84U PD=60.84U
* device instance $82 r0 *1 185.96,188.95 pfet
M$82 VDD GDRV VDD VDD pfet L=20U W=30U AS=12.6P AD=12.6P PS=60.84U PD=60.84U
* device instance $83 r0 *1 207.2,188.95 pfet
M$83 VDD GDRV VDD VDD pfet L=20U W=30U AS=12.6P AD=12.6P PS=60.84U PD=60.84U
* device instance $84 r0 *1 228.44,188.95 pfet
M$84 VDD GDRV VDD VDD pfet L=20U W=30U AS=12.6P AD=12.6P PS=60.84U PD=60.84U
* device instance $85 r0 *1 21.01,1.31 pnp
Q$85 VSS VSS VA pnp AE=0.4624P PE=2.72U AB=0.7744P PB=3.52U AC=0.7744P PC=3.52U
+ NE=1
* device instance $86 r0 *1 22.91,1.31 pnp
Q$86 VSS VSS VA pnp AE=0.4624P PE=2.72U AB=0.7744P PB=3.52U AC=0.7744P PC=3.52U
+ NE=1
* device instance $87 r0 *1 24.81,1.31 pnp
Q$87 VSS VSS VA pnp AE=0.4624P PE=2.72U AB=0.7744P PB=3.52U AC=0.7744P PC=3.52U
+ NE=1
* device instance $88 r0 *1 26.71,1.31 pnp
Q$88 VSS VSS VA pnp AE=0.4624P PE=2.72U AB=0.7744P PB=3.52U AC=0.7744P PC=3.52U
+ NE=1
* device instance $89 r0 *1 21.01,2.39 pnp
Q$89 VSS VSS VA pnp AE=0.4624P PE=2.72U AB=0.7744P PB=3.52U AC=0.7744P PC=3.52U
+ NE=1
* device instance $90 r0 *1 22.91,2.39 pnp
Q$90 VSS VSS VA pnp AE=0.4624P PE=2.72U AB=0.7744P PB=3.52U AC=0.7744P PC=3.52U
+ NE=1
* device instance $91 r0 *1 24.81,2.39 pnp
Q$91 VSS VSS VA pnp AE=0.4624P PE=2.72U AB=0.7744P PB=3.52U AC=0.7744P PC=3.52U
+ NE=1
* device instance $92 r0 *1 26.71,2.39 pnp
Q$92 VSS VSS VA pnp AE=0.4624P PE=2.72U AB=0.7744P PB=3.52U AC=0.7744P PC=3.52U
+ NE=1
* device instance $93 r0 *1 268.43,2.67 pnp
Q$93 VSS VSS VBQ pnp AE=11.56P PE=13.6U AB=12.96P PB=14.4U AC=12.96P PC=14.4U
+ NE=1
* device instance $94 r0 *1 273.05,2.67 pnp
Q$94 VSS VSS VBQ pnp AE=11.56P PE=13.6U AB=12.96P PB=14.4U AC=12.96P PC=14.4U
+ NE=1
* device instance $95 r0 *1 277.67,2.67 pnp
Q$95 VSS VSS VBQ pnp AE=11.56P PE=13.6U AB=12.96P PB=14.4U AC=12.96P PC=14.4U
+ NE=1
* device instance $96 r0 *1 282.29,2.67 pnp
Q$96 VSS VSS VBQ pnp AE=11.56P PE=13.6U AB=12.96P PB=14.4U AC=12.96P PC=14.4U
+ NE=1
* device instance $97 r0 *1 268.43,6.47 pnp
Q$97 VSS VSS VBQ pnp AE=11.56P PE=13.6U AB=12.96P PB=14.4U AC=12.96P PC=14.4U
+ NE=1
* device instance $98 r0 *1 273.05,6.47 pnp
Q$98 VSS VSS VBQ pnp AE=11.56P PE=13.6U AB=12.96P PB=14.4U AC=12.96P PC=14.4U
+ NE=1
* device instance $99 r0 *1 277.67,6.47 pnp
Q$99 VSS VSS VBQ pnp AE=11.56P PE=13.6U AB=12.96P PB=14.4U AC=12.96P PC=14.4U
+ NE=1
* device instance $100 r0 *1 282.29,6.47 pnp
Q$100 VSS VSS VBQ pnp AE=11.56P PE=13.6U AB=12.96P PB=14.4U AC=12.96P PC=14.4U
+ NE=1
* device instance $101 r0 *1 62.34,0.5 res_high_po
R$101 VOUT \$6 VSS 2003.841367 res_high_po
* device instance $102 r0 *1 68.68,0.5 res_high_po
R$102 VOUT \$7 VSS 2003.841367 res_high_po
* device instance $103 r0 *1 75.02,0.5 res_high_po
R$103 \$6 \$8 VSS 2003.841367 res_high_po
* device instance $104 r0 *1 81.36,0.5 res_high_po
R$104 \$7 \$9 VSS 2003.841367 res_high_po
* device instance $105 r0 *1 87.7,0.5 res_high_po
R$105 \$8 \$10 VSS 2003.841367 res_high_po
* device instance $106 r0 *1 94.04,0.5 res_high_po
R$106 \$9 \$11 VSS 2003.841367 res_high_po
* device instance $107 r0 *1 100.38,0.5 res_high_po
R$107 \$10 \$12 VSS 2003.841367 res_high_po
* device instance $108 r0 *1 106.72,0.5 res_high_po
R$108 \$11 \$13 VSS 2003.841367 res_high_po
* device instance $109 r0 *1 113.06,0.5 res_high_po
R$109 \$12 \$14 VSS 2003.841367 res_high_po
* device instance $110 r0 *1 119.4,0.5 res_high_po
R$110 \$13 \$15 VSS 2003.841367 res_high_po
* device instance $111 r0 *1 62.34,3.3 res_high_po
R$111 \$20 \$35 VSS 2003.841367 res_high_po
* device instance $112 r0 *1 62.34,1.9 res_high_po
R$112 \$21 \$22 VSS 2003.841367 res_high_po
* device instance $113 r0 *1 68.68,1.9 res_high_po
R$113 \$20 \$23 VSS 2003.841367 res_high_po
* device instance $114 r0 *1 68.68,3.3 res_high_po
R$114 \$21 \$36 VSS 2003.841367 res_high_po
* device instance $115 r0 *1 75.02,1.9 res_high_po
R$115 \$22 \$24 VSS 2003.841367 res_high_po
* device instance $116 r0 *1 75.02,3.3 res_high_po
R$116 \$35 \$37 VSS 2003.841367 res_high_po
* device instance $117 r0 *1 81.36,3.3 res_high_po
R$117 \$36 \$38 VSS 2003.841367 res_high_po
* device instance $118 r0 *1 81.36,1.9 res_high_po
R$118 \$23 \$25 VSS 2003.841367 res_high_po
* device instance $119 r0 *1 87.7,1.9 res_high_po
R$119 \$24 \$26 VSS 2003.841367 res_high_po
* device instance $120 r0 *1 87.7,3.3 res_high_po
R$120 \$37 \$39 VSS 2003.841367 res_high_po
* device instance $121 r0 *1 94.04,1.9 res_high_po
R$121 \$25 \$27 VSS 2003.841367 res_high_po
* device instance $122 r0 *1 94.04,3.3 res_high_po
R$122 \$38 \$40 VSS 2003.841367 res_high_po
* device instance $123 r0 *1 100.38,3.3 res_high_po
R$123 \$39 \$41 VSS 2003.841367 res_high_po
* device instance $124 r0 *1 100.38,1.9 res_high_po
R$124 \$26 \$28 VSS 2003.841367 res_high_po
* device instance $125 r0 *1 106.72,3.3 res_high_po
R$125 \$40 \$42 VSS 2003.841367 res_high_po
* device instance $126 r0 *1 106.72,1.9 res_high_po
R$126 \$27 \$29 VSS 2003.841367 res_high_po
* device instance $127 r0 *1 113.06,3.3 res_high_po
R$127 \$41 \$43 VSS 2003.841367 res_high_po
* device instance $128 r0 *1 113.06,1.9 res_high_po
R$128 \$28 \$15 VSS 2003.841367 res_high_po
* device instance $129 r0 *1 119.4,3.3 res_high_po
R$129 \$42 \$44 VSS 2003.841367 res_high_po
* device instance $130 r0 *1 119.4,1.9 res_high_po
R$130 \$29 \$14 VSS 2003.841367 res_high_po
* device instance $131 r0 *1 62.34,4.7 res_high_po
R$131 \$46 \$47 VSS 2003.841367 res_high_po
* device instance $132 r0 *1 68.68,4.7 res_high_po
R$132 \$45 \$48 VSS 2003.841367 res_high_po
* device instance $133 r0 *1 75.02,4.7 res_high_po
R$133 \$47 \$49 VSS 2003.841367 res_high_po
* device instance $134 r0 *1 81.36,4.7 res_high_po
R$134 \$48 \$50 VSS 2003.841367 res_high_po
* device instance $135 r0 *1 87.7,4.7 res_high_po
R$135 \$49 \$51 VSS 2003.841367 res_high_po
* device instance $136 r0 *1 94.04,4.7 res_high_po
R$136 \$50 \$52 VSS 2003.841367 res_high_po
* device instance $137 r0 *1 100.38,4.7 res_high_po
R$137 \$51 \$53 VSS 2003.841367 res_high_po
* device instance $138 r0 *1 106.72,4.7 res_high_po
R$138 \$52 \$54 VSS 2003.841367 res_high_po
* device instance $139 r0 *1 113.06,4.7 res_high_po
R$139 \$53 \$44 VSS 2003.841367 res_high_po
* device instance $140 r0 *1 119.4,4.7 res_high_po
R$140 \$54 \$43 VSS 2003.841367 res_high_po
* device instance $141 r0 *1 62.34,6.1 res_high_po
R$141 \$45 \$55 VSS 2003.841367 res_high_po
* device instance $142 r0 *1 68.68,6.1 res_high_po
R$142 \$46 \$56 VSS 2003.841367 res_high_po
* device instance $143 r0 *1 75.02,6.1 res_high_po
R$143 \$55 \$57 VSS 2003.841367 res_high_po
* device instance $144 r0 *1 81.36,6.1 res_high_po
R$144 \$56 \$58 VSS 2003.841367 res_high_po
* device instance $145 r0 *1 87.7,6.1 res_high_po
R$145 \$57 \$59 VSS 2003.841367 res_high_po
* device instance $146 r0 *1 94.04,6.1 res_high_po
R$146 \$58 \$60 VSS 2003.841367 res_high_po
* device instance $147 r0 *1 100.38,6.1 res_high_po
R$147 \$59 \$61 VSS 2003.841367 res_high_po
* device instance $148 r0 *1 106.72,6.1 res_high_po
R$148 \$60 \$62 VSS 2003.841367 res_high_po
* device instance $149 r0 *1 113.06,6.1 res_high_po
R$149 \$61 \$63 VSS 2003.841367 res_high_po
* device instance $150 r0 *1 119.4,6.1 res_high_po
R$150 \$62 \$64 VSS 2003.841367 res_high_po
* device instance $151 r0 *1 62.34,7.5 res_high_po
R$151 \$66 \$67 VSS 2003.841367 res_high_po
* device instance $152 r0 *1 68.68,7.5 res_high_po
R$152 \$65 \$68 VSS 2003.841367 res_high_po
* device instance $153 r0 *1 75.02,7.5 res_high_po
R$153 \$67 \$69 VSS 2003.841367 res_high_po
* device instance $154 r0 *1 81.36,7.5 res_high_po
R$154 \$68 \$70 VSS 2003.841367 res_high_po
* device instance $155 r0 *1 87.7,7.5 res_high_po
R$155 \$69 \$71 VSS 2003.841367 res_high_po
* device instance $156 r0 *1 94.04,7.5 res_high_po
R$156 \$70 \$72 VSS 2003.841367 res_high_po
* device instance $157 r0 *1 100.38,7.5 res_high_po
R$157 \$71 \$73 VSS 2003.841367 res_high_po
* device instance $158 r0 *1 106.72,7.5 res_high_po
R$158 \$72 \$74 VSS 2003.841367 res_high_po
* device instance $159 r0 *1 113.06,7.5 res_high_po
R$159 \$73 \$64 VSS 2003.841367 res_high_po
* device instance $160 r0 *1 119.4,7.5 res_high_po
R$160 \$74 \$63 VSS 2003.841367 res_high_po
* device instance $161 r0 *1 62.34,8.9 res_high_po
R$161 \$65 \$77 VSS 2003.841367 res_high_po
* device instance $162 r0 *1 68.68,8.9 res_high_po
R$162 \$66 \$78 VSS 2003.841367 res_high_po
* device instance $163 r0 *1 75.02,8.9 res_high_po
R$163 \$77 \$79 VSS 2003.841367 res_high_po
* device instance $164 r0 *1 81.36,8.9 res_high_po
R$164 \$78 \$80 VSS 2003.841367 res_high_po
* device instance $165 r0 *1 87.7,8.9 res_high_po
R$165 \$79 \$81 VSS 2003.841367 res_high_po
* device instance $166 r0 *1 94.04,8.9 res_high_po
R$166 \$80 \$83 VSS 2003.841367 res_high_po
* device instance $167 r0 *1 100.38,8.9 res_high_po
R$167 \$81 \$84 VSS 2003.841367 res_high_po
* device instance $168 r0 *1 106.72,8.9 res_high_po
R$168 \$83 \$85 VSS 2003.841367 res_high_po
* device instance $169 r0 *1 113.06,8.9 res_high_po
R$169 \$84 \$86 VSS 2003.841367 res_high_po
* device instance $170 r0 *1 119.4,8.9 res_high_po
R$170 \$85 \$99 VSS 2003.841367 res_high_po
* device instance $171 r0 *1 142.67,8.9 res_high_po
R$171 \$82 \$89 VSS 542.118769 res_high_po
* device instance $172 r0 *1 144.51,8.9 res_high_po
R$172 \$100 \$90 VSS 542.118769 res_high_po
* device instance $173 r0 *1 146.35,8.9 res_high_po
R$173 \$89 \$91 VSS 542.118769 res_high_po
* device instance $174 r0 *1 148.19,8.9 res_high_po
R$174 \$90 \$92 VSS 542.118769 res_high_po
* device instance $175 r0 *1 150.03,8.9 res_high_po
R$175 \$91 \$93 VSS 542.118769 res_high_po
* device instance $176 r0 *1 151.87,8.9 res_high_po
R$176 \$92 \$94 VSS 542.118769 res_high_po
* device instance $177 r0 *1 153.71,8.9 res_high_po
R$177 \$93 \$95 VSS 542.118769 res_high_po
* device instance $178 r0 *1 155.55,8.9 res_high_po
R$178 \$94 \$96 VSS 542.118769 res_high_po
* device instance $179 r0 *1 157.39,8.9 res_high_po
R$179 \$95 \$97 VSS 542.118769 res_high_po
* device instance $180 r0 *1 159.23,8.9 res_high_po
R$180 \$96 \$102 VSS 542.118769 res_high_po
* device instance $181 r0 *1 62.34,11.7 res_high_po
R$181 \$98 \$121 VSS 2003.841367 res_high_po
* device instance $182 r0 *1 62.34,10.3 res_high_po
R$182 \$103 \$104 VSS 2003.841367 res_high_po
* device instance $183 r0 *1 68.68,11.7 res_high_po
R$183 \$103 \$122 VSS 2003.841367 res_high_po
* device instance $184 r0 *1 68.68,10.3 res_high_po
R$184 \$98 \$105 VSS 2003.841367 res_high_po
* device instance $185 r0 *1 75.02,11.7 res_high_po
R$185 \$121 \$123 VSS 2003.841367 res_high_po
* device instance $186 r0 *1 75.02,10.3 res_high_po
R$186 \$104 \$106 VSS 2003.841367 res_high_po
* device instance $187 r0 *1 81.36,10.3 res_high_po
R$187 \$105 \$107 VSS 2003.841367 res_high_po
* device instance $188 r0 *1 81.36,11.7 res_high_po
R$188 \$122 \$124 VSS 2003.841367 res_high_po
* device instance $189 r0 *1 87.7,10.3 res_high_po
R$189 \$106 \$108 VSS 2003.841367 res_high_po
* device instance $190 r0 *1 87.7,11.7 res_high_po
R$190 \$123 \$125 VSS 2003.841367 res_high_po
* device instance $191 r0 *1 94.04,10.3 res_high_po
R$191 \$107 \$109 VSS 2003.841367 res_high_po
* device instance $192 r0 *1 94.04,11.7 res_high_po
R$192 \$124 \$126 VSS 2003.841367 res_high_po
* device instance $193 r0 *1 100.38,10.3 res_high_po
R$193 \$108 \$110 VSS 2003.841367 res_high_po
* device instance $194 r0 *1 100.38,11.7 res_high_po
R$194 \$125 \$127 VSS 2003.841367 res_high_po
* device instance $195 r0 *1 106.72,10.3 res_high_po
R$195 \$109 \$111 VSS 2003.841367 res_high_po
* device instance $196 r0 *1 106.72,11.7 res_high_po
R$196 \$126 \$128 VSS 2003.841367 res_high_po
* device instance $197 r0 *1 113.06,10.3 res_high_po
R$197 \$110 \$99 VSS 2003.841367 res_high_po
* device instance $198 r0 *1 113.06,11.7 res_high_po
R$198 \$127 \$129 VSS 2003.841367 res_high_po
* device instance $199 r0 *1 119.4,10.3 res_high_po
R$199 \$111 \$86 VSS 2003.841367 res_high_po
* device instance $200 r0 *1 119.4,11.7 res_high_po
R$200 \$128 \$130 VSS 2003.841367 res_high_po
* device instance $201 r0 *1 142.67,10.3 res_high_po
R$201 \$112 \$113 VSS 542.118769 res_high_po
* device instance $202 r0 *1 142.67,11.7 res_high_po
R$202 \$101 \$131 VSS 542.118769 res_high_po
* device instance $203 r0 *1 144.51,10.3 res_high_po
R$203 \$101 \$114 VSS 542.118769 res_high_po
* device instance $204 r0 *1 144.51,11.7 res_high_po
R$204 \$112 \$132 VSS 542.118769 res_high_po
* device instance $205 r0 *1 146.35,11.7 res_high_po
R$205 \$131 \$133 VSS 542.118769 res_high_po
* device instance $206 r0 *1 146.35,10.3 res_high_po
R$206 \$113 \$115 VSS 542.118769 res_high_po
* device instance $207 r0 *1 148.19,11.7 res_high_po
R$207 \$132 \$134 VSS 542.118769 res_high_po
* device instance $208 r0 *1 148.19,10.3 res_high_po
R$208 \$114 \$116 VSS 542.118769 res_high_po
* device instance $209 r0 *1 150.03,11.7 res_high_po
R$209 \$133 \$135 VSS 542.118769 res_high_po
* device instance $210 r0 *1 150.03,10.3 res_high_po
R$210 \$115 \$117 VSS 542.118769 res_high_po
* device instance $211 r0 *1 151.87,11.7 res_high_po
R$211 \$134 \$136 VSS 542.118769 res_high_po
* device instance $212 r0 *1 151.87,10.3 res_high_po
R$212 \$116 \$118 VSS 542.118769 res_high_po
* device instance $213 r0 *1 153.71,11.7 res_high_po
R$213 \$135 \$137 VSS 542.118769 res_high_po
* device instance $214 r0 *1 153.71,10.3 res_high_po
R$214 \$117 \$119 VSS 542.118769 res_high_po
* device instance $215 r0 *1 155.55,10.3 res_high_po
R$215 \$118 \$120 VSS 542.118769 res_high_po
* device instance $216 r0 *1 155.55,11.7 res_high_po
R$216 \$136 \$138 VSS 542.118769 res_high_po
* device instance $217 r0 *1 157.39,11.7 res_high_po
R$217 \$137 \$139 VSS 542.118769 res_high_po
* device instance $218 r0 *1 157.39,10.3 res_high_po
R$218 \$119 \$102 VSS 542.118769 res_high_po
* device instance $219 r0 *1 159.23,11.7 res_high_po
R$219 \$138 \$140 VSS 542.118769 res_high_po
* device instance $220 r0 *1 159.23,10.3 res_high_po
R$220 \$120 \$97 VSS 542.118769 res_high_po
* device instance $221 r0 *1 87.7,13.1 res_high_po
R$221 \$100 \$143 VSS 2003.841367 res_high_po
* device instance $222 r0 *1 94.04,13.1 res_high_po
R$222 \$82 \$144 VSS 2003.841367 res_high_po
* device instance $223 r0 *1 100.38,13.1 res_high_po
R$223 \$143 \$145 VSS 2003.841367 res_high_po
* device instance $224 r0 *1 106.72,13.1 res_high_po
R$224 \$144 \$146 VSS 2003.841367 res_high_po
* device instance $225 r0 *1 113.06,13.1 res_high_po
R$225 \$145 \$130 VSS 2003.841367 res_high_po
* device instance $226 r0 *1 119.4,13.1 res_high_po
R$226 \$146 \$129 VSS 2003.841367 res_high_po
* device instance $227 r0 *1 142.67,13.1 res_high_po
R$227 VB \$149 VSS 542.118769 res_high_po
* device instance $228 r0 *1 144.51,13.1 res_high_po
R$228 VA \$150 VSS 542.118769 res_high_po
* device instance $229 r0 *1 146.35,13.1 res_high_po
R$229 \$149 \$151 VSS 542.118769 res_high_po
* device instance $230 r0 *1 148.19,13.1 res_high_po
R$230 \$150 \$152 VSS 542.118769 res_high_po
* device instance $231 r0 *1 150.03,13.1 res_high_po
R$231 \$151 \$153 VSS 542.118769 res_high_po
* device instance $232 r0 *1 151.87,13.1 res_high_po
R$232 \$152 \$154 VSS 542.118769 res_high_po
* device instance $233 r0 *1 153.71,13.1 res_high_po
R$233 \$153 \$155 VSS 542.118769 res_high_po
* device instance $234 r0 *1 155.55,13.1 res_high_po
R$234 \$154 \$156 VSS 542.118769 res_high_po
* device instance $235 r0 *1 157.39,13.1 res_high_po
R$235 \$155 \$140 VSS 542.118769 res_high_po
* device instance $236 r0 *1 159.23,13.1 res_high_po
R$236 \$156 \$139 VSS 542.118769 res_high_po
* device instance $237 r0 *1 191.5,13.1 res_high_po
R$237 VB \$159 VSS 2003.841367 res_high_po
* device instance $238 r0 *1 197.84,13.1 res_high_po
R$238 \$159 \$160 VSS 2003.841367 res_high_po
* device instance $239 r0 *1 204.18,13.1 res_high_po
R$239 \$160 \$161 VSS 2003.841367 res_high_po
* device instance $240 r0 *1 210.52,13.1 res_high_po
R$240 \$161 \$162 VSS 2003.841367 res_high_po
* device instance $241 r0 *1 216.86,13.1 res_high_po
R$241 \$162 \$163 VSS 2003.841367 res_high_po
* device instance $242 r0 *1 223.2,13.1 res_high_po
R$242 \$163 \$164 VSS 2003.841367 res_high_po
* device instance $243 r0 *1 229.54,13.1 res_high_po
R$243 \$164 VBQ VSS 2003.841367 res_high_po
.ENDS bandgap_core_routed
