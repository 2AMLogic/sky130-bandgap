* layout/bandgap-core/reference.spice -- the xschem-derived LVS reference
* netlist for the bandgap core (issue #8's schematic, issue #62's LVS pair).
*
* Transcribed (modulo `.param` substitution and the klt LVS reader's own
* device-card conventions) from design/bandgap_core.sch with
* design/error_amp.sch expanded -- the live schematic, whose CORE_PARAMS
* block carries n_r2 = 50 (issue #99/PR #105, DR-003's closure; was n_r2=54
* before that resize -- see the RESISTOR VALUE CONVENTION note below for why
* the resize changes the VALUES on the R cards below even though it does
* not touch design/bandgap_core.sch's own XR1/XR2A/XR2B lines, which still
* model each leg as a single device).
*
* Checked-in netlist evidence for the resized parameter set:
*   sim/res-array-resize/records/20260805-204809-2c83c7a.md
* (n_r1=7, n_r2=50; the chained-array R1/R2A/R2B table this file's own R
* cards are transcribed from). The pre-resize n_r2=54 snapshot this file
* previously cited,
* sim/output-voltage-tc/netlist-snapshots/20260803-115356-7759435.spice
* (byte-identical to the earlier .../20260803-102002-32194bc.spice), still
* exists and is still correct evidence for the *topology* (device list,
* node names, terminal orders) -- only the numeric n_r2 and the R-card
* VALUES below moved. Both predate the DR-002 trim parameters (n_r2_trim /
* r_lseg_trim), which are no-ops at code 0 and so do not change the
* topology either way.
*
* PROVENANCE CORRECTION: an earlier revision of this file cited
* sim/output-voltage-tc/netlist-snapshots/20260803-142220-b24b404.spice as
* its source. That snapshot carries `.param n_r2=55` -- the candidate commit
* 297073f (issue #57) records as REJECTED (it loses the bandgap operating
* point above ~124 degC at ff/2.97 V and fs/2.97 V). The transcribed values
* here were always the n_r2=54 design values; only the citation was wrong.
*
* INPUT-PAIR CORRECTION: an earlier revision of this file transcribed the
* amp's differential inputs the wrong way round (`MMP1 ... VA` / `MMP2 ... VB`).
* The schematic says the opposite, and the mapping is worth writing down
* because it survives no relabeling -- D1 and D2 are distinguishable in the
* graph (D1 drives MMN3 -> GDRV, D2 drives MMN4 -> PN), so a VA<->VB rename
* would have to move R1 and Q1's emitter too, and those are already correct:
*   design/error_amp.sym    VINP pin box at symbol-relative (-50, -20),
*                           VINN at (-50, +20); header: "VINP non-inverting
*                           input (AOUT rises when VINP rises)".
*   design/bandgap_core.sch XAMP instantiated at 900 -600 rot 0 flip 0, so
*                           VINP lands on (850, -620) = `ampp lab=VB` and
*                           VINN on (850, -580) = `ampn lab=VA`.
*   design/error_amp.sch    MP1 gate = VINP (mp1g), MP2 gate = VINN (mp2g);
*                           MP1 drain = D1, MP2 drain = D2.
*   => flattened: MMP1 D1 VB TAIL VDD  and  MMP2 D2 VA TAIL VDD.
* The checked-in snapshot cited below agrees:
*   `XAMP VB VA GDRV TAIL VDD VSS error_amp` against
*   `.subckt error_amp VINP VINN AOUT ITAIL VDD VSS`.
* VINP = VB is also what makes the loop negative-feedback: VB is the
* higher-impedance leg (R1 + r_Q2 vs r_Q1), so it moves more per volt of
* VOUT. The previous transcription described a positive-feedback amplifier.
* The rest of the VA/VB assignments were, and remain, as the schematic has
* them: R2A on VA (`r2am lab=VA`), R2B on VB (`r2bm lab=VB`), R1's head on
* VB (`r1p lab=VB`) with its tail on VBQ, Q1's emitter on VA (`q1e lab=VA`)
* and Q2's emitter on VBQ (`q2e lab=VBQ`).
*
* Parameters (design/bandgap_core.sch CORE_PARAMS, design/error_amp.sch):
*   n_pnp_ctat = n_pnp_ptat = 8      r_w = 1     r_lseg = 5
*   n_r1 = 7    n_r2 = 50            n_r2_trim = 0 (untrimmed, code 0)
*   m_out = m_ampbias = 2
*   amp_m_in = 16   amp_m_nmirr = 4   amp_m_pmirr = 8   amp_m_cc = 16
*
* This file is the *schematic side* of LVS. It is deliberately NOT derived
* from the layout: the whole point of the comparison is that the two were
* produced independently. Device multiplicity is carried as `m=` on each
* card (the layout draws `m` physical instances of each), and R2A/R2B carry
* their untrimmed length `r_lseg * n_r2 = 250u`; the trim ladder's taps are
* a metal option (DR-002) that does not change code-0 topology.
*
* The `res_high_po` model name on the R cards below is the schematic's own
* device (design/bandgap_core.sch instantiates sky130_fd_pr__res_high_po on
* every leg). An earlier revision named `res_generic_po` instead, because
* that was the only flavour `klt gen res_array` could draw; the reference has
* no business tracking the layout's tooling limits, and since
* 2AMLogic/klayout-tools#463 merged there is no limit to track.
*
* RESISTOR VALUE CONVENTION (issue #108, deciding the question DR-003's
* closure and issue #99 left open): the R cards below now state the
* CHAINED value -- the sum every drawn unit-instance primitive in
* layout/bin/gen_bandgap_routed.py's res_r2/res_trim/res_r1 decomposition
* pays, using the real sky130_fd_pr__res_high_po SPICE model's own two-term
* form (sheet_rho_ohm_sq=324.827244, fixed_offset_ohm=379.705147 per
* instance) -- NOT the single-device approximation
* (design/bandgap_core.sch line 188's `R ~ 380 + 325*L` once per leg) this
* file used before. Two things make this the right convention for an *LVS
* reference*, as opposed to design/bandgap_core.sch's own XR1/XR2A/XR2B
* lines (which correctly stay single-device -- they are a SIZING model, not
* an LVS reference, and issue #99's resize was verified against exactly
* this chained value, not the single-device one):
*   1. It is what `klt lvs` actually reads. The layout never builds R2A/
*      R2B/R1 as one device -- `bus_res_series` chains many separately-
*      contacted `res_high_po` unit primitives so `klt draw`'s met1 jumpers
*      can reach every DR-002 trim tap (RES_TRIM_LENGTH_NOTE in
*      gen_bandgap_routed.py) -- and `klt lvs`'s own `combine_devices`
*      folds that chain by SUMMING each primitive's corrected `r`, which
*      charges the fixed per-instance head/end term once per primitive, not
*      once per logical device (RES_HEAD_RESISTANCE_NOTE). Stating the
*      single-device approximation here would leave a residual `r`
*      mismatch that is not a layout defect and not informative -- exactly
*      the gap issue #62's twenty-third increment (PR #97) measured and
*      left open (mismatch_count unchanged at 4, R2 off by +26,152.7 ohm
*      under the single-device convention).
*   2. It is the value issue #99's own PVT re-verification used. The n_r2
*      54->50 resize (sim/res-array-resize/records/20260805-204809-
*      2c83c7a.md) was sized and verified against this same chained value,
*      not the single-device one -- so this file now states the same
*      number DR-003's closure certifies as the fabricated part's real
*      resistance, rather than a number nothing in this repo's evidence
*      base claims the real part reaches.
* This intentionally makes `klt lvs`'s value comparison closer to
* passing where it previously disclosed a real, quantified gap (see the
* RESISTOR VALUE DERIVATION block below and the routed record's own
* `mismatch_count`); that is the point, not a side effect to be wary of --
* the prior single-device values were never a claim about what the
* fabricated part's resistors measure.
*
* RESISTOR VALUE DERIVATION (chained, per the convention above). Per-
* instance: r_body = sheet_rho_ohm_sq * L_um (W = r_w = 1 um, so squares =
* L_um) + fixed_offset_ohm, summed over every drawn primitive in the leg:
*   R1  = 7 * (324.827244*5 + 379.705147)               = 14026.89 ohm
*         (res_r1: 7 unit instances, 5 um each, no trim ladder on R1)
*   R2A = R2B = 46*(324.827244*5 + 379.705147)
*             + 20*(324.827244*1 + 379.705147)          = 106267.35 ohm
*         (res_r2: 46 coarse 5 um instances; res_trim: 20 fine 1 um
*         instances -- the issue #91 decomposition, re-transcribed to the
*         resized n_r2=50/46-coarse count by issue #108; see
*         gen_bandgap_routed.py's N_R1/N_R2_COARSE/N_R2_TRIM_UNITS)
*   K = R2/R1 = 106267.35/14026.89 = 7.5760   (not n_r2/n_r1 = 7.1429; each
*       leg's head/end resistance total differs because R1 and R2 chain a
*       different PRIMITIVE COUNT, 7 vs 66, not just a different length)
* Values verified to the digit against sim/res-array-resize/records/
* 20260805-204809-2c83c7a.md's own "Chained-array resistance the resize
* targets" table (independently produced by chaining real ngspice
* res_high_po device-model instances, not this formula).
*
* KNOWN LAYOUT-SIDE GAPS, disclosed here rather than modelled away:
*   - The amp's output and the core mirror's gate drive are ONE net in the
*     schematic (`XAMP VB VA GDRV TAIL VDD VSS error_amp` ties error_amp's
*     AOUT opin straight to bandgap_core's GDRV iopin); this file therefore
*     names that single node `GDRV` throughout, with no device between the
*     amp drain and the mirror gates. A previous revision of this file
*     bridged the layout's then-separate `AOUT`/`GDRV` pins with a 0-ohm
*     `RGDRV AOUT GDRV 0` card, which made the reference a 17-device netlist
*     with a device the schematic does not contain, purely to accommodate the
*     layout. That is removed, and the layout now draws the node as one:
*     the reference states the schematic, and the record states the layout.
*   - `VOUT` likewise joins MPOUT's drain and both R2A/R2B tops here, as in
*     the schematic. Whether the layout draws that join is stated in the
*     routed record's own coverage table, not accommodated here.
*
* RESISTOR BULK-TERMINAL CORRECTION (issue #62, sixteenth increment): the
* R2A/R2B/R1 cards below now carry a third (bulk) node, `VSS`, matching
* design/bandgap_core.sch's own explicit wiring -- `r2ab`/`r2bb`/`r1b` are
* all `lab_pin`s reading `VSS` (design/bandgap_core.sch lines 258/267/283),
* and the checked-in xschem netlist this file already cites as its source
* (sim/output-voltage-tc/netlist-snapshots/20260803-115356-7759435.spice)
* confirms it: `XR2A VA VOUT VSS sky130_fd_pr__res_high_po ...`. A prior
* revision of this file dropped that third node, on the mistaken assumption
* that adding one would mean inventing a connection the schematic does not
* make -- it does; `sky130_fd_pr__res_high_po`'s own PDK model
* (`.subckt sky130_fd_pr__res_high_po r0 r1 b ...`) is a genuine 3-terminal
* device, and the schematic instantiates it as one. This is a transcription
* fix, not a layout accommodation: nothing about `klt`'s tooling or this
* repo's layout choices motivates it, and the value carried on the bulk
* node (`VSS`) is exactly what the schematic itself wires, not a value
* chosen to make LVS pass. Before this fix `klt lvs`'s SPICE reader parsed
* these 2-terminal `R` cards as `DeviceClassResistor`, which cannot pair
* against the layout's 3-terminal `DeviceClassResistorWithBulk` reading of
* the same device class name (klayout-tools#504) regardless of value --
* the comparer never got far enough to compare resistance at all. The
* generic upstream reconciliation for that shape (klayout-tools#506, filed
* by the fifteenth increment) stays open but is not a dependency here: it
* exists for references that genuinely cannot state a bulk net, and this
* one always could. See layout/matching-plan.md Sections 7m and 7n for the
* filing and the measured LVS effect respectively.
*
* Previously this section also disclosed that every nfet/resistor/PNP bulk
* terminal in the layout extracted onto sky130's deck-synthesized `vsubs`
* global rather than the drawn `VSS` this file names, requiring a
* `hints.same_nets` declaration to bridge the two. That cause is retired as
* of issue #62's fourteenth increment (2AMLogic/klayout-tools#490, merged
* via #495): a real drawn substrate tap now resolves the deck's single
* global substrate identity to the real `VSS` net directly, and the flow
* sends no `hints.same_nets` entry any more -- see
* layout/matching-plan.md Section 7l.
*
* Terminal orders follow KLayout's SPICE reader defaults for each device
* class the sky130 extraction deck registers:
*   M<name> D G S B <model>            (nfet/pfet)
*   Q<name> C B E <model>              (pnp)
*   R<name> A B BULK <value> <model>   (res_high_po; deck-marked
*                                        `bulk_to_substrate`, confirmed
*                                        against this flow's own extracted
*                                        netlist, e.g. `R$85 VOUT $6 VSS
*                                        1599 res_high_po`)
*
* PNP EMITTER-GEOMETRY CORRECTION (issue #62, twenty-first increment): the
* QQ1/QQ2 cards below now carry `AE`/`PE`/`NE`, matching KLayout's own
* `DeviceClassBJT3Transistor` parameter set (`AE` emitter area, `PE` emitter
* perimeter, `NE` emitter count -- `klt lvs`'s SPICE reader has no notion of
* a `M`/`mult` field for this device class at all; unlike `DeviceClassMOS3Transistor`,
* where a bare `m=` IS folded into `W` at read time (confirmed directly with
* `klayout.db.NetlistSpiceReader`), a Q-card's `m=8` is silently dropped and
* every unstated BJT3 parameter defaults to its class default (`AE`/`PE`/`AB`/
* `PB`/`AC`/`PC` = 0, `NE` = 1) -- which is exactly the shape `klt lvs`
* reported before this fix: `ne` 8 (layout) vs 1 (reference), plus zero-valued
* `ae`/`pe`/`ab`/`pb`/`ac`/`pc`.
*
* `AE`/`PE` ARE knowable independent of this repo's own layout generator: the
* instantiated model name IS the vendor's geometry declaration --
* `sky130_fd_pr__pnp_05v5_W0p68L0p68`/`_W3p40L3p40` are SkyWater's own fixed,
* non-parametric macro cells (`sky130_fd_pr/pnp_05v5.sym`'s netlist format is
* `... sky130_fd_pr__@model m=@m`, with no W/L/area argument at all -- the
* `.subckt`s in libs.ref/sky130_fd_pr/spice/sky130_fd_pr__pnp_05v5_W*.model.spice
* take only `Collector Base Emitter` plus a `mult` param; every geometry-
* dependent SPICE parameter, e.g. `is`/`bf`, is baked into that specific
* model's own `.subckt`/`.model` cards). The vendor's own naming convention
* encodes the emitter's W and L directly, so the standard SPICE
* rectangular-junction formulae give
*   AE = W*L,  PE = 2*(W+L)
* per unit, and the schematic's own `m='n_pnp_ctat'`/`m='n_pnp_ptat'` (= 8,
* design/bandgap_core.sch line 186-187) states the parallel count, which
* `klt lvs`'s `combine_devices` sums into `AE`/`PE` (not just `NE`) when it
* folds the layout's own 8 parallel unit devices into one -- confirmed
* directly against this flow's own combined-LVS device table, where the
* layout's post-fold Q1 reads `AE=3.6992 PE=21.76 NE=8` and Q2 reads
* `AE=92.48 PE=108.8 NE=8`, i.e. exactly `8 * unit_AE` / `8 * unit_PE`, not
* `unit_AE` unscaled:
*   Q1 (W0p68L0p68): unit AE = 0.68*0.68  = 0.4624 um^2, unit PE = 2*(0.68+0.68) = 2.72 um
*                    x8:      AE = 3.6992 um^2,                PE = 21.76 um
*   Q2 (W3p40L3p40): unit AE = 3.40*3.40  = 11.56  um^2, unit PE = 2*(3.40+3.40) = 13.6  um
*                    x8:      AE = 92.48  um^2,                PE = 108.8  um
* Verified with `klayout.db.NetlistSpiceReader` directly: a Q-card carrying
* these `AE`/`PE`/`NE` values round-trips to the identical parameter table
* the layout's combined device reports, closing all three of `ae`/`pe`/`ne`
* per device (6 of the 14 device.property mismatches these two devices carried).
*
* `AB`/`PB`/`AC`/`PC` (base/collector area/perimeter) are deliberately left
* unstated (0, the class default) and remain mismatched. Unlike the emitter,
* base/collector geometry is NOT part of the vendor's fixed macro at all --
* this layout does not instantiate `sky130_fd_pr__pnp_05v5_W*` as a vendor
* cell; `klt gen bjt_array` draws a "matching-faithful floorplan from base
* layers" (see the routed record's own "What this record does NOT claim"
* section), so the drawn base/collector geometry (well/tap margins, etc.) is
* this repository's own generator's choice, not something
* design/bandgap_core.sch's `model=pnp_05v5_W*` name declares or could ever
* declare. Stating a value here would mean deriving it from the layout to
* make the comparison pass -- the workaround this file's own convention
* (see the RESISTOR BULK-TERMINAL CORRECTION note above) refuses. See
* layout/matching-plan.md Section 7r.

.subckt bandgap_core VOUT GDRV VDD VSS
* ---- core PMOS mirror (MPOUT / MPAMP), W=8 L=2, mult=2 each -------------
MMPOUT VOUT GDRV VDD VDD pfet L=2U W=8U m=2
MMPAMP TAIL GDRV VDD VDD pfet L=2U W=8U m=2
* ---- error amplifier (design/error_amp.sch), flattened -----------------
* The amp's output node IS the core's gate-drive node (schematic AOUT/GDRV).
* MP1's gate is VINP = VB; MP2's gate is VINN = VA (see INPUT-PAIR CORRECTION).
MMP1  D1   VB   TAIL VDD pfet L=10U W=20U m=16
MMP2  D2   VA   TAIL VDD pfet L=10U W=20U m=16
MMN1  D1   D1   VSS  VSS nfet L=20U W=8U  m=4
MMN2  D2   D2   VSS  VSS nfet L=20U W=8U  m=4
MMN3  GDRV D1   VSS  VSS nfet L=20U W=8U  m=4
MMN4  PN   D2   VSS  VSS nfet L=20U W=8U  m=4
MMP4  GDRV PN   VDD  VDD pfet L=20U W=6U  m=8
MMP3  PN   PN   VDD  VDD pfet L=20U W=6U  m=8
MMCC  VDD  GDRV VDD  VDD pfet L=20U W=30U m=16
* ---- divider legs: R2A/R2B, W=1 L=250 (n_r2=50 x r_lseg=5) -------------
* Chained value (RESISTOR VALUE CONVENTION/DERIVATION above): 106267.35 ohm,
* not the single-device 380+325*250=81630 ohm design/bandgap_core.sch's own
* unit model would give this leg's length -- see that note for why.
* Bulk (3rd node) = VSS, per design/bandgap_core.sch `r2ab`/`r2bb` lab_pins.
RR2A VA  VOUT VSS 106267.35 res_high_po
RR2B VB  VOUT VSS 106267.35 res_high_po
* ---- dVBE leg: R1, W=1 L=35 (n_r1=7 x r_lseg=5, unchanged by the resize) --
* Chained value: 14026.89 ohm, not the single-device 380+325*35=11755 ohm.
* Bulk (3rd node) = VSS, per design/bandgap_core.sch `r1b` lab_pin.
RR1  VBQ VB   VSS 14026.89 res_high_po
* ---- PNP pair, diode-connected (base and collector to VSS) -------------
* AE/PE/NE per the PNP EMITTER-GEOMETRY CORRECTION note above (derived from
* the vendor's own fixed W0p68L0p68/W3p40L3p40 macro geometry, x8 units);
* AB/PB/AC/PC deliberately left unstated (0, this device class's default).
QQ1 VSS VSS VA  pnp AE=3.6992P PE=21.76U NE=8
QQ2 VSS VSS VBQ pnp AE=92.48P  PE=108.8U NE=8
.ends bandgap_core
