* extracted by klt extract --deck sky130

* cell bandgap_core_routed
* pin D1
* pin D1_GATE
* pin D1_MIRROR_GATE
* pin D2
* pin D2_GATE
* pin D2_MIRROR_GATE
* pin GDRV
* pin GDRV_GATE
* pin PN
* pin PN_GATE
* pin TAIL
* pin TRIM_A
* pin TRIM_A_CODE_0
* pin TRIM_B
* pin TRIM_B_CODE_0
* pin VA
* pin VA_GATE
* pin VB
* pin VBQ
* pin VB_GATE
* pin VDD
* pin VOUT
* pin VSS
* pin vsubs
.SUBCKT bandgap_core_routed D1 D1_GATE D1_MIRROR_GATE D2 D2_GATE D2_MIRROR_GATE
+ GDRV GDRV_GATE PN PN_GATE TAIL TRIM_A TRIM_A_CODE_0 TRIM_B TRIM_B_CODE_0 VA
+ VA_GATE VB VBQ VB_GATE VDD VOUT VSS vsubs
* device instance $1 r0 *1 225.14,45.27 nfet
M$1 VSS \$235 D1 vsubs nfet L=20U W=8U AS=3.36P AD=3.36P PS=16.84U PD=16.84U
* device instance $2 r0 *1 246.38,45.27 nfet
M$2 \$263 D2_GATE \$261 vsubs nfet L=20U W=8U AS=3.36P AD=3.36P PS=16.84U
+ PD=16.84U
* device instance $3 r0 *1 267.62,45.27 nfet
M$3 \$266 \$237 \$264 vsubs nfet L=20U W=8U AS=3.36P AD=3.36P PS=16.84U
+ PD=16.84U
* device instance $4 r0 *1 288.86,45.27 nfet
M$4 \$269 \$238 \$267 vsubs nfet L=20U W=8U AS=3.36P AD=3.36P PS=16.84U
+ PD=16.84U
* device instance $5 r0 *1 225.14,53.67 nfet
M$5 VSS \$260 D2 vsubs nfet L=20U W=8U AS=3.36P AD=3.36P PS=16.84U PD=16.84U
* device instance $6 r0 *1 246.38,53.67 nfet
M$6 \$306 D1_GATE \$304 vsubs nfet L=20U W=8U AS=3.36P AD=3.36P PS=16.84U
+ PD=16.84U
* device instance $7 r0 *1 267.62,53.67 nfet
M$7 \$309 \$265 \$307 vsubs nfet L=20U W=8U AS=3.36P AD=3.36P PS=16.84U
+ PD=16.84U
* device instance $8 r0 *1 288.86,53.67 nfet
M$8 \$311 \$268 \$310 vsubs nfet L=20U W=8U AS=3.36P AD=3.36P PS=16.84U
+ PD=16.84U
* device instance $9 r0 *1 210.07,91.66 nfet
M$9 VSS D2_MIRROR_GATE PN vsubs nfet L=20U W=8U AS=3.36P AD=3.36P PS=16.84U
+ PD=16.84U
* device instance $10 r0 *1 231.31,91.66 nfet
M$10 \$345 \$303 \$343 vsubs nfet L=20U W=8U AS=3.36P AD=3.36P PS=16.84U
+ PD=16.84U
* device instance $11 r0 *1 252.55,91.66 nfet
M$11 \$348 \$305 \$346 vsubs nfet L=20U W=8U AS=3.36P AD=3.36P PS=16.84U
+ PD=16.84U
* device instance $12 r0 *1 273.79,91.66 nfet
M$12 \$351 \$308 \$349 vsubs nfet L=20U W=8U AS=3.36P AD=3.36P PS=16.84U
+ PD=16.84U
* device instance $13 r0 *1 210.07,100.06 nfet
M$13 VSS D1_MIRROR_GATE GDRV vsubs nfet L=20U W=8U AS=3.36P AD=3.36P PS=16.84U
+ PD=16.84U
* device instance $14 r0 *1 231.31,100.06 nfet
M$14 \$369 \$344 \$368 vsubs nfet L=20U W=8U AS=3.36P AD=3.36P PS=16.84U
+ PD=16.84U
* device instance $15 r0 *1 252.55,100.06 nfet
M$15 \$371 \$347 \$370 vsubs nfet L=20U W=8U AS=3.36P AD=3.36P PS=16.84U
+ PD=16.84U
* device instance $16 r0 *1 273.79,100.06 nfet
M$16 \$373 \$350 \$372 vsubs nfet L=20U W=8U AS=3.36P AD=3.36P PS=16.84U
+ PD=16.84U
* device instance $17 r0 *1 26.71,39.27 pfet
M$17 \$190 \$189 \$188 VDD pfet L=10U W=20U AS=8.4P AD=8.4P PS=40.84U PD=40.84U
* device instance $18 r0 *1 37.95,39.27 pfet
M$18 \$193 VB_GATE \$191 VDD pfet L=10U W=20U AS=8.4P AD=8.4P PS=40.84U
+ PD=40.84U
* device instance $19 r0 *1 49.19,39.27 pfet
M$19 \$196 \$195 \$194 VDD pfet L=10U W=20U AS=8.4P AD=8.4P PS=40.84U PD=40.84U
* device instance $20 r0 *1 60.43,39.27 pfet
M$20 \$198 \$197 TAIL VDD pfet L=10U W=20U AS=8.4P AD=8.4P PS=40.84U PD=40.84U
* device instance $21 r0 *1 71.67,39.27 pfet
M$21 \$201 \$200 \$199 VDD pfet L=10U W=20U AS=8.4P AD=8.4P PS=40.84U PD=40.84U
* device instance $22 r0 *1 82.91,39.27 pfet
M$22 \$204 \$203 \$202 VDD pfet L=10U W=20U AS=8.4P AD=8.4P PS=40.84U PD=40.84U
* device instance $23 r0 *1 94.15,39.27 pfet
M$23 \$207 \$206 \$205 VDD pfet L=10U W=20U AS=8.4P AD=8.4P PS=40.84U PD=40.84U
* device instance $24 r0 *1 105.39,39.27 pfet
M$24 \$210 \$209 \$208 VDD pfet L=10U W=20U AS=8.4P AD=8.4P PS=40.84U PD=40.84U
* device instance $25 r0 *1 116.63,39.27 pfet
M$25 \$213 \$212 \$211 VDD pfet L=10U W=20U AS=8.4P AD=8.4P PS=40.84U PD=40.84U
* device instance $26 r0 *1 127.87,39.27 pfet
M$26 \$216 \$215 \$214 VDD pfet L=10U W=20U AS=8.4P AD=8.4P PS=40.84U PD=40.84U
* device instance $27 r0 *1 139.11,39.27 pfet
M$27 \$219 \$218 \$217 VDD pfet L=10U W=20U AS=8.4P AD=8.4P PS=40.84U PD=40.84U
* device instance $28 r0 *1 150.35,39.27 pfet
M$28 \$222 \$221 \$220 VDD pfet L=10U W=20U AS=8.4P AD=8.4P PS=40.84U PD=40.84U
* device instance $29 r0 *1 161.59,39.27 pfet
M$29 \$225 \$224 \$223 VDD pfet L=10U W=20U AS=8.4P AD=8.4P PS=40.84U PD=40.84U
* device instance $30 r0 *1 172.83,39.27 pfet
M$30 D1 \$227 \$226 VDD pfet L=10U W=20U AS=8.4P AD=8.4P PS=40.84U PD=40.84U
* device instance $31 r0 *1 184.07,39.27 pfet
M$31 \$231 \$230 \$229 VDD pfet L=10U W=20U AS=8.4P AD=8.4P PS=40.84U PD=40.84U
* device instance $32 r0 *1 195.31,39.27 pfet
M$32 \$234 \$233 \$232 VDD pfet L=10U W=20U AS=8.4P AD=8.4P PS=40.84U PD=40.84U
* device instance $33 r0 *1 2.49,45.27 pfet
M$33 VOUT \$186 \$239 VDD pfet L=2U W=8U AS=3.36P AD=3.36P PS=16.84U PD=16.84U
* device instance $34 r0 *1 2.49,53.67 pfet
M$34 \$270 \$240 VDD VDD pfet L=2U W=8U AS=3.36P AD=3.36P PS=16.84U PD=16.84U
* device instance $35 r0 *1 5.73,53.67 pfet
M$35 \$271 GDRV_GATE VDD VDD pfet L=2U W=8U AS=3.36P AD=3.36P PS=16.84U
+ PD=16.84U
* device instance $36 r0 *1 5.73,45.27 pfet
M$36 TAIL \$187 \$241 VDD pfet L=2U W=8U AS=3.36P AD=3.36P PS=16.84U PD=16.84U
* device instance $37 r0 *1 26.71,59.67 pfet
M$37 \$273 \$244 \$272 VDD pfet L=10U W=20U AS=8.4P AD=8.4P PS=40.84U PD=40.84U
* device instance $38 r0 *1 37.95,59.67 pfet
M$38 \$275 VA_GATE \$274 VDD pfet L=10U W=20U AS=8.4P AD=8.4P PS=40.84U
+ PD=40.84U
* device instance $39 r0 *1 49.19,59.67 pfet
M$39 \$277 \$246 \$276 VDD pfet L=10U W=20U AS=8.4P AD=8.4P PS=40.84U PD=40.84U
* device instance $40 r0 *1 60.43,59.67 pfet
M$40 \$279 \$247 \$278 VDD pfet L=10U W=20U AS=8.4P AD=8.4P PS=40.84U PD=40.84U
* device instance $41 r0 *1 71.67,59.67 pfet
M$41 \$280 \$248 VDD VDD pfet L=10U W=20U AS=8.4P AD=8.4P PS=40.84U PD=40.84U
* device instance $42 r0 *1 82.91,59.67 pfet
M$42 \$281 \$249 VDD VDD pfet L=10U W=20U AS=8.4P AD=8.4P PS=40.84U PD=40.84U
* device instance $43 r0 *1 94.15,59.67 pfet
M$43 \$283 \$250 \$282 VDD pfet L=10U W=20U AS=8.4P AD=8.4P PS=40.84U PD=40.84U
* device instance $44 r0 *1 105.39,59.67 pfet
M$44 \$285 \$251 \$284 VDD pfet L=10U W=20U AS=8.4P AD=8.4P PS=40.84U PD=40.84U
* device instance $45 r0 *1 116.63,59.67 pfet
M$45 \$287 \$252 \$286 VDD pfet L=10U W=20U AS=8.4P AD=8.4P PS=40.84U PD=40.84U
* device instance $46 r0 *1 127.87,59.67 pfet
M$46 \$289 \$253 \$288 VDD pfet L=10U W=20U AS=8.4P AD=8.4P PS=40.84U PD=40.84U
* device instance $47 r0 *1 139.11,59.67 pfet
M$47 \$291 \$254 \$290 VDD pfet L=10U W=20U AS=8.4P AD=8.4P PS=40.84U PD=40.84U
* device instance $48 r0 *1 150.35,59.67 pfet
M$48 \$293 \$255 \$292 VDD pfet L=10U W=20U AS=8.4P AD=8.4P PS=40.84U PD=40.84U
* device instance $49 r0 *1 161.59,59.67 pfet
M$49 \$295 \$256 \$294 VDD pfet L=10U W=20U AS=8.4P AD=8.4P PS=40.84U PD=40.84U
* device instance $50 r0 *1 172.83,59.67 pfet
M$50 D2 \$257 \$296 VDD pfet L=10U W=20U AS=8.4P AD=8.4P PS=40.84U PD=40.84U
* device instance $51 r0 *1 184.07,59.67 pfet
M$51 \$299 \$258 \$298 VDD pfet L=10U W=20U AS=8.4P AD=8.4P PS=40.84U PD=40.84U
* device instance $52 r0 *1 195.31,59.67 pfet
M$52 \$302 \$259 \$300 VDD pfet L=10U W=20U AS=8.4P AD=8.4P PS=40.84U PD=40.84U
* device instance $53 r0 *1 26.56,99.06 pfet
M$53 \$353 \$321 \$352 VDD pfet L=20U W=6U AS=2.52P AD=2.52P PS=12.84U PD=12.84U
* device instance $54 r0 *1 26.56,92.66 pfet
M$54 \$322 \$312 \$320 VDD pfet L=20U W=6U AS=2.52P AD=2.52P PS=12.84U PD=12.84U
* device instance $55 r0 *1 47.8,99.06 pfet
M$55 \$355 PN_GATE \$354 VDD pfet L=20U W=6U AS=2.52P AD=2.52P PS=12.84U
+ PD=12.84U
* device instance $56 r0 *1 47.8,92.66 pfet
M$56 \$325 \$313 \$323 VDD pfet L=20U W=6U AS=2.52P AD=2.52P PS=12.84U PD=12.84U
* device instance $57 r0 *1 69.04,99.06 pfet
M$57 \$357 \$326 \$356 VDD pfet L=20U W=6U AS=2.52P AD=2.52P PS=12.84U PD=12.84U
* device instance $58 r0 *1 69.04,92.66 pfet
M$58 \$327 \$314 VDD VDD pfet L=20U W=6U AS=2.52P AD=2.52P PS=12.84U PD=12.84U
* device instance $59 r0 *1 90.28,92.66 pfet
M$59 \$329 \$315 VDD VDD pfet L=20U W=6U AS=2.52P AD=2.52P PS=12.84U PD=12.84U
* device instance $60 r0 *1 90.28,99.06 pfet
M$60 \$359 \$328 \$358 VDD pfet L=20U W=6U AS=2.52P AD=2.52P PS=12.84U PD=12.84U
* device instance $61 r0 *1 111.52,92.66 pfet
M$61 \$332 \$316 \$330 VDD pfet L=20U W=6U AS=2.52P AD=2.52P PS=12.84U PD=12.84U
* device instance $62 r0 *1 111.52,99.06 pfet
M$62 \$361 \$331 \$360 VDD pfet L=20U W=6U AS=2.52P AD=2.52P PS=12.84U PD=12.84U
* device instance $63 r0 *1 132.76,92.66 pfet
M$63 \$335 \$317 \$333 VDD pfet L=20U W=6U AS=2.52P AD=2.52P PS=12.84U PD=12.84U
* device instance $64 r0 *1 132.76,99.06 pfet
M$64 \$363 \$334 \$362 VDD pfet L=20U W=6U AS=2.52P AD=2.52P PS=12.84U PD=12.84U
* device instance $65 r0 *1 154,99.06 pfet
M$65 GDRV \$337 \$364 VDD pfet L=20U W=6U AS=2.52P AD=2.52P PS=12.84U PD=12.84U
* device instance $66 r0 *1 154,92.66 pfet
M$66 PN \$318 \$336 VDD pfet L=20U W=6U AS=2.52P AD=2.52P PS=12.84U PD=12.84U
* device instance $67 r0 *1 175.24,99.06 pfet
M$67 \$367 \$340 \$366 VDD pfet L=20U W=6U AS=2.52P AD=2.52P PS=12.84U PD=12.84U
* device instance $68 r0 *1 175.24,92.66 pfet
M$68 \$341 \$319 \$339 VDD pfet L=20U W=6U AS=2.52P AD=2.52P PS=12.84U PD=12.84U
* device instance $69 r0 *1 9.77,1.31 pnp
Q$69 vsubs VSS \$22 pnp AE=0.4624P PE=2.72U AB=0.7744P PB=3.52U AC=0.7744P
+ PC=3.52U NE=1
* device instance $70 r0 *1 11.67,1.31 pnp
Q$70 vsubs VSS VA pnp AE=0.4624P PE=2.72U AB=0.7744P PB=3.52U AC=0.7744P
+ PC=3.52U NE=1
* device instance $71 r0 *1 13.57,1.31 pnp
Q$71 vsubs VSS VA pnp AE=0.4624P PE=2.72U AB=0.7744P PB=3.52U AC=0.7744P
+ PC=3.52U NE=1
* device instance $72 r0 *1 15.47,1.31 pnp
Q$72 vsubs VSS VA pnp AE=0.4624P PE=2.72U AB=0.7744P PB=3.52U AC=0.7744P
+ PC=3.52U NE=1
* device instance $73 r0 *1 17.37,1.31 pnp
Q$73 vsubs VSS VA pnp AE=0.4624P PE=2.72U AB=0.7744P PB=3.52U AC=0.7744P
+ PC=3.52U NE=1
* device instance $74 r0 *1 19.27,1.31 pnp
Q$74 vsubs VSS \$24 pnp AE=0.4624P PE=2.72U AB=0.7744P PB=3.52U AC=0.7744P
+ PC=3.52U NE=1
* device instance $75 r0 *1 9.77,2.39 pnp
Q$75 vsubs VSS \$37 pnp AE=0.4624P PE=2.72U AB=0.7744P PB=3.52U AC=0.7744P
+ PC=3.52U NE=1
* device instance $76 r0 *1 11.67,2.39 pnp
Q$76 vsubs VSS VA pnp AE=0.4624P PE=2.72U AB=0.7744P PB=3.52U AC=0.7744P
+ PC=3.52U NE=1
* device instance $77 r0 *1 13.57,2.39 pnp
Q$77 vsubs VSS VA pnp AE=0.4624P PE=2.72U AB=0.7744P PB=3.52U AC=0.7744P
+ PC=3.52U NE=1
* device instance $78 r0 *1 15.47,2.39 pnp
Q$78 vsubs VSS VA pnp AE=0.4624P PE=2.72U AB=0.7744P PB=3.52U AC=0.7744P
+ PC=3.52U NE=1
* device instance $79 r0 *1 17.37,2.39 pnp
Q$79 vsubs VSS VA pnp AE=0.4624P PE=2.72U AB=0.7744P PB=3.52U AC=0.7744P
+ PC=3.52U NE=1
* device instance $80 r0 *1 19.27,2.39 pnp
Q$80 vsubs VSS \$38 pnp AE=0.4624P PE=2.72U AB=0.7744P PB=3.52U AC=0.7744P
+ PC=3.52U NE=1
* device instance $81 r0 *1 265.15,2.67 pnp
Q$81 vsubs VSS \$39 pnp AE=11.56P PE=13.6U AB=12.96P PB=14.4U AC=12.96P
+ PC=14.4U NE=1
* device instance $82 r0 *1 269.77,2.67 pnp
Q$82 vsubs VSS VBQ pnp AE=11.56P PE=13.6U AB=12.96P PB=14.4U AC=12.96P PC=14.4U
+ NE=1
* device instance $83 r0 *1 274.39,2.67 pnp
Q$83 vsubs VSS VBQ pnp AE=11.56P PE=13.6U AB=12.96P PB=14.4U AC=12.96P PC=14.4U
+ NE=1
* device instance $84 r0 *1 279.01,2.67 pnp
Q$84 vsubs VSS VBQ pnp AE=11.56P PE=13.6U AB=12.96P PB=14.4U AC=12.96P PC=14.4U
+ NE=1
* device instance $85 r0 *1 283.63,2.67 pnp
Q$85 vsubs VSS VBQ pnp AE=11.56P PE=13.6U AB=12.96P PB=14.4U AC=12.96P PC=14.4U
+ NE=1
* device instance $86 r0 *1 288.25,2.67 pnp
Q$86 vsubs VSS \$41 pnp AE=11.56P PE=13.6U AB=12.96P PB=14.4U AC=12.96P
+ PC=14.4U NE=1
* device instance $87 r0 *1 265.15,6.47 pnp
Q$87 vsubs VSS \$80 pnp AE=11.56P PE=13.6U AB=12.96P PB=14.4U AC=12.96P
+ PC=14.4U NE=1
* device instance $88 r0 *1 269.77,6.47 pnp
Q$88 vsubs VSS VBQ pnp AE=11.56P PE=13.6U AB=12.96P PB=14.4U AC=12.96P PC=14.4U
+ NE=1
* device instance $89 r0 *1 274.39,6.47 pnp
Q$89 vsubs VSS VBQ pnp AE=11.56P PE=13.6U AB=12.96P PB=14.4U AC=12.96P PC=14.4U
+ NE=1
* device instance $90 r0 *1 279.01,6.47 pnp
Q$90 vsubs VSS VBQ pnp AE=11.56P PE=13.6U AB=12.96P PB=14.4U AC=12.96P PC=14.4U
+ NE=1
* device instance $91 r0 *1 283.63,6.47 pnp
Q$91 vsubs VSS VBQ pnp AE=11.56P PE=13.6U AB=12.96P PB=14.4U AC=12.96P PC=14.4U
+ NE=1
* device instance $92 r0 *1 288.25,6.47 pnp
Q$92 vsubs VSS \$81 pnp AE=11.56P PE=13.6U AB=12.96P PB=14.4U AC=12.96P
+ PC=14.4U NE=1
* device instance $93 r0 *1 36.32,0.5 res_generic_po
R$93 \$5 \$6 241 res_generic_po
* device instance $94 r0 *1 42.66,0.5 res_generic_po
R$94 \$7 \$8 241 res_generic_po
* device instance $95 r0 *1 49,0.5 res_generic_po
R$95 VOUT \$9 241 res_generic_po
* device instance $96 r0 *1 55.34,0.5 res_generic_po
R$96 VOUT \$10 241 res_generic_po
* device instance $97 r0 *1 61.68,0.5 res_generic_po
R$97 \$9 \$11 241 res_generic_po
* device instance $98 r0 *1 68.02,0.5 res_generic_po
R$98 \$10 \$12 241 res_generic_po
* device instance $99 r0 *1 74.36,0.5 res_generic_po
R$99 \$11 \$13 241 res_generic_po
* device instance $100 r0 *1 80.7,0.5 res_generic_po
R$100 \$12 \$14 241 res_generic_po
* device instance $101 r0 *1 87.04,0.5 res_generic_po
R$101 \$13 \$15 241 res_generic_po
* device instance $102 r0 *1 93.38,0.5 res_generic_po
R$102 \$14 \$16 241 res_generic_po
* device instance $103 r0 *1 99.72,0.5 res_generic_po
R$103 \$15 \$17 241 res_generic_po
* device instance $104 r0 *1 106.06,0.5 res_generic_po
R$104 \$16 \$18 241 res_generic_po
* device instance $105 r0 *1 112.4,0.5 res_generic_po
R$105 \$17 \$19 241 res_generic_po
* device instance $106 r0 *1 118.74,0.5 res_generic_po
R$106 \$18 \$20 241 res_generic_po
* device instance $107 r0 *1 49,3.3 res_generic_po
R$107 \$25 \$42 241 res_generic_po
* device instance $108 r0 *1 49,1.9 res_generic_po
R$108 \$26 \$27 241 res_generic_po
* device instance $109 r0 *1 55.34,3.3 res_generic_po
R$109 \$26 \$43 241 res_generic_po
* device instance $110 r0 *1 55.34,1.9 res_generic_po
R$110 \$25 \$28 241 res_generic_po
* device instance $111 r0 *1 61.68,1.9 res_generic_po
R$111 \$27 \$29 241 res_generic_po
* device instance $112 r0 *1 61.68,3.3 res_generic_po
R$112 \$42 \$44 241 res_generic_po
* device instance $113 r0 *1 68.02,1.9 res_generic_po
R$113 \$28 \$30 241 res_generic_po
* device instance $114 r0 *1 68.02,3.3 res_generic_po
R$114 \$43 \$45 241 res_generic_po
* device instance $115 r0 *1 74.36,1.9 res_generic_po
R$115 \$29 \$31 241 res_generic_po
* device instance $116 r0 *1 74.36,3.3 res_generic_po
R$116 \$44 \$46 241 res_generic_po
* device instance $117 r0 *1 80.7,3.3 res_generic_po
R$117 \$45 \$47 241 res_generic_po
* device instance $118 r0 *1 80.7,1.9 res_generic_po
R$118 \$30 \$32 241 res_generic_po
* device instance $119 r0 *1 87.04,1.9 res_generic_po
R$119 \$31 \$33 241 res_generic_po
* device instance $120 r0 *1 87.04,3.3 res_generic_po
R$120 \$46 \$48 241 res_generic_po
* device instance $121 r0 *1 93.38,1.9 res_generic_po
R$121 \$32 \$34 241 res_generic_po
* device instance $122 r0 *1 93.38,3.3 res_generic_po
R$122 \$47 \$49 241 res_generic_po
* device instance $123 r0 *1 99.72,3.3 res_generic_po
R$123 \$48 \$50 241 res_generic_po
* device instance $124 r0 *1 99.72,1.9 res_generic_po
R$124 \$33 \$35 241 res_generic_po
* device instance $125 r0 *1 106.06,3.3 res_generic_po
R$125 \$49 \$51 241 res_generic_po
* device instance $126 r0 *1 106.06,1.9 res_generic_po
R$126 \$34 \$36 241 res_generic_po
* device instance $127 r0 *1 112.4,3.3 res_generic_po
R$127 \$50 \$52 241 res_generic_po
* device instance $128 r0 *1 112.4,1.9 res_generic_po
R$128 \$35 \$20 241 res_generic_po
* device instance $129 r0 *1 118.74,3.3 res_generic_po
R$129 \$51 \$53 241 res_generic_po
* device instance $130 r0 *1 118.74,1.9 res_generic_po
R$130 \$36 \$19 241 res_generic_po
* device instance $131 r0 *1 49,4.7 res_generic_po
R$131 \$55 \$56 241 res_generic_po
* device instance $132 r0 *1 55.34,4.7 res_generic_po
R$132 \$54 \$57 241 res_generic_po
* device instance $133 r0 *1 61.68,4.7 res_generic_po
R$133 \$56 \$58 241 res_generic_po
* device instance $134 r0 *1 68.02,4.7 res_generic_po
R$134 \$57 \$59 241 res_generic_po
* device instance $135 r0 *1 74.36,4.7 res_generic_po
R$135 \$58 \$60 241 res_generic_po
* device instance $136 r0 *1 80.7,4.7 res_generic_po
R$136 \$59 \$61 241 res_generic_po
* device instance $137 r0 *1 87.04,4.7 res_generic_po
R$137 \$60 \$62 241 res_generic_po
* device instance $138 r0 *1 93.38,4.7 res_generic_po
R$138 \$61 \$63 241 res_generic_po
* device instance $139 r0 *1 99.72,4.7 res_generic_po
R$139 \$62 \$64 241 res_generic_po
* device instance $140 r0 *1 106.06,4.7 res_generic_po
R$140 \$63 \$65 241 res_generic_po
* device instance $141 r0 *1 112.4,4.7 res_generic_po
R$141 \$64 \$53 241 res_generic_po
* device instance $142 r0 *1 118.74,4.7 res_generic_po
R$142 \$65 \$52 241 res_generic_po
* device instance $143 r0 *1 49,6.1 res_generic_po
R$143 \$54 \$66 241 res_generic_po
* device instance $144 r0 *1 55.34,6.1 res_generic_po
R$144 \$55 \$67 241 res_generic_po
* device instance $145 r0 *1 61.68,6.1 res_generic_po
R$145 \$66 \$68 241 res_generic_po
* device instance $146 r0 *1 68.02,6.1 res_generic_po
R$146 \$67 \$69 241 res_generic_po
* device instance $147 r0 *1 74.36,6.1 res_generic_po
R$147 \$68 \$70 241 res_generic_po
* device instance $148 r0 *1 80.7,6.1 res_generic_po
R$148 \$69 \$71 241 res_generic_po
* device instance $149 r0 *1 87.04,6.1 res_generic_po
R$149 \$70 \$72 241 res_generic_po
* device instance $150 r0 *1 93.38,6.1 res_generic_po
R$150 \$71 \$73 241 res_generic_po
* device instance $151 r0 *1 99.72,6.1 res_generic_po
R$151 \$72 \$74 241 res_generic_po
* device instance $152 r0 *1 106.06,6.1 res_generic_po
R$152 \$73 \$75 241 res_generic_po
* device instance $153 r0 *1 112.4,6.1 res_generic_po
R$153 \$74 \$76 241 res_generic_po
* device instance $154 r0 *1 118.74,6.1 res_generic_po
R$154 \$75 \$77 241 res_generic_po
* device instance $155 r0 *1 49,7.5 res_generic_po
R$155 \$82 \$83 241 res_generic_po
* device instance $156 r0 *1 55.34,7.5 res_generic_po
R$156 \$78 \$84 241 res_generic_po
* device instance $157 r0 *1 61.68,7.5 res_generic_po
R$157 \$83 \$85 241 res_generic_po
* device instance $158 r0 *1 68.02,7.5 res_generic_po
R$158 \$84 \$86 241 res_generic_po
* device instance $159 r0 *1 74.36,7.5 res_generic_po
R$159 \$85 \$87 241 res_generic_po
* device instance $160 r0 *1 80.7,7.5 res_generic_po
R$160 \$86 \$88 241 res_generic_po
* device instance $161 r0 *1 87.04,7.5 res_generic_po
R$161 \$87 \$89 241 res_generic_po
* device instance $162 r0 *1 93.38,7.5 res_generic_po
R$162 \$88 \$90 241 res_generic_po
* device instance $163 r0 *1 99.72,7.5 res_generic_po
R$163 \$89 \$91 241 res_generic_po
* device instance $164 r0 *1 106.06,7.5 res_generic_po
R$164 \$90 \$92 241 res_generic_po
* device instance $165 r0 *1 112.4,7.5 res_generic_po
R$165 \$91 \$77 241 res_generic_po
* device instance $166 r0 *1 118.74,7.5 res_generic_po
R$166 \$92 \$76 241 res_generic_po
* device instance $167 r0 *1 147.26,7.5 res_generic_po
R$167 \$93 \$94 48.2 res_generic_po
* device instance $168 r0 *1 149.6,7.5 res_generic_po
R$168 \$95 \$96 48.2 res_generic_po
* device instance $169 r0 *1 151.94,7.5 res_generic_po
R$169 TRIM_A TRIM_A_CODE_0 48.2 res_generic_po
* device instance $170 r0 *1 154.28,7.5 res_generic_po
R$170 TRIM_B TRIM_B_CODE_0 48.2 res_generic_po
* device instance $171 r0 *1 156.62,7.5 res_generic_po
R$171 TRIM_A_CODE_0 \$99 48.2 res_generic_po
* device instance $172 r0 *1 158.96,7.5 res_generic_po
R$172 TRIM_B_CODE_0 \$100 48.2 res_generic_po
* device instance $173 r0 *1 161.3,7.5 res_generic_po
R$173 \$99 \$101 48.2 res_generic_po
* device instance $174 r0 *1 163.64,7.5 res_generic_po
R$174 \$100 \$102 48.2 res_generic_po
* device instance $175 r0 *1 165.98,7.5 res_generic_po
R$175 \$101 \$103 48.2 res_generic_po
* device instance $176 r0 *1 168.32,7.5 res_generic_po
R$176 \$102 \$104 48.2 res_generic_po
* device instance $177 r0 *1 49,8.9 res_generic_po
R$177 \$78 \$105 241 res_generic_po
* device instance $178 r0 *1 49,10.3 res_generic_po
R$178 \$126 \$127 241 res_generic_po
* device instance $179 r0 *1 55.34,10.3 res_generic_po
R$179 \$124 \$128 241 res_generic_po
* device instance $180 r0 *1 55.34,8.9 res_generic_po
R$180 \$82 \$106 241 res_generic_po
* device instance $181 r0 *1 61.68,8.9 res_generic_po
R$181 \$105 \$107 241 res_generic_po
* device instance $182 r0 *1 61.68,10.3 res_generic_po
R$182 \$127 \$129 241 res_generic_po
* device instance $183 r0 *1 68.02,8.9 res_generic_po
R$183 \$106 \$108 241 res_generic_po
* device instance $184 r0 *1 68.02,10.3 res_generic_po
R$184 \$128 \$130 241 res_generic_po
* device instance $185 r0 *1 74.36,10.3 res_generic_po
R$185 \$129 \$131 241 res_generic_po
* device instance $186 r0 *1 74.36,8.9 res_generic_po
R$186 \$107 \$109 241 res_generic_po
* device instance $187 r0 *1 80.7,10.3 res_generic_po
R$187 \$130 \$132 241 res_generic_po
* device instance $188 r0 *1 80.7,8.9 res_generic_po
R$188 \$108 \$110 241 res_generic_po
* device instance $189 r0 *1 87.04,10.3 res_generic_po
R$189 \$131 \$133 241 res_generic_po
* device instance $190 r0 *1 87.04,8.9 res_generic_po
R$190 \$109 \$111 241 res_generic_po
* device instance $191 r0 *1 93.38,10.3 res_generic_po
R$191 \$132 \$134 241 res_generic_po
* device instance $192 r0 *1 93.38,8.9 res_generic_po
R$192 \$110 \$112 241 res_generic_po
* device instance $193 r0 *1 99.72,8.9 res_generic_po
R$193 \$111 \$113 241 res_generic_po
* device instance $194 r0 *1 99.72,10.3 res_generic_po
R$194 \$133 \$135 241 res_generic_po
* device instance $195 r0 *1 106.06,10.3 res_generic_po
R$195 \$134 \$136 241 res_generic_po
* device instance $196 r0 *1 106.06,8.9 res_generic_po
R$196 \$112 \$114 241 res_generic_po
* device instance $197 r0 *1 112.4,10.3 res_generic_po
R$197 \$135 \$125 241 res_generic_po
* device instance $198 r0 *1 112.4,8.9 res_generic_po
R$198 \$113 \$115 241 res_generic_po
* device instance $199 r0 *1 118.74,8.9 res_generic_po
R$199 \$114 \$125 241 res_generic_po
* device instance $200 r0 *1 118.74,10.3 res_generic_po
R$200 \$136 \$115 241 res_generic_po
* device instance $201 r0 *1 151.94,10.3 res_generic_po
R$201 \$116 \$137 48.2 res_generic_po
* device instance $202 r0 *1 151.94,8.9 res_generic_po
R$202 \$117 \$118 48.2 res_generic_po
* device instance $203 r0 *1 154.28,8.9 res_generic_po
R$203 \$116 \$119 48.2 res_generic_po
* device instance $204 r0 *1 154.28,10.3 res_generic_po
R$204 \$117 \$138 48.2 res_generic_po
* device instance $205 r0 *1 156.62,8.9 res_generic_po
R$205 \$118 \$120 48.2 res_generic_po
* device instance $206 r0 *1 156.62,10.3 res_generic_po
R$206 \$137 \$139 48.2 res_generic_po
* device instance $207 r0 *1 158.96,10.3 res_generic_po
R$207 \$138 \$140 48.2 res_generic_po
* device instance $208 r0 *1 158.96,8.9 res_generic_po
R$208 \$119 \$121 48.2 res_generic_po
* device instance $209 r0 *1 161.3,8.9 res_generic_po
R$209 \$120 \$122 48.2 res_generic_po
* device instance $210 r0 *1 161.3,10.3 res_generic_po
R$210 \$139 \$141 48.2 res_generic_po
* device instance $211 r0 *1 163.64,8.9 res_generic_po
R$211 \$121 \$123 48.2 res_generic_po
* device instance $212 r0 *1 163.64,10.3 res_generic_po
R$212 \$140 \$142 48.2 res_generic_po
* device instance $213 r0 *1 165.98,10.3 res_generic_po
R$213 \$141 \$143 48.2 res_generic_po
* device instance $214 r0 *1 165.98,8.9 res_generic_po
R$214 \$122 \$104 48.2 res_generic_po
* device instance $215 r0 *1 168.32,8.9 res_generic_po
R$215 \$123 \$103 48.2 res_generic_po
* device instance $216 r0 *1 168.32,10.3 res_generic_po
R$216 \$142 \$144 48.2 res_generic_po
* device instance $217 r0 *1 49,11.7 res_generic_po
R$217 \$124 \$145 241 res_generic_po
* device instance $218 r0 *1 55.34,11.7 res_generic_po
R$218 \$126 \$146 241 res_generic_po
* device instance $219 r0 *1 61.68,11.7 res_generic_po
R$219 \$145 \$147 241 res_generic_po
* device instance $220 r0 *1 68.02,11.7 res_generic_po
R$220 \$146 \$148 241 res_generic_po
* device instance $221 r0 *1 74.36,11.7 res_generic_po
R$221 \$147 \$149 241 res_generic_po
* device instance $222 r0 *1 80.7,11.7 res_generic_po
R$222 \$148 \$150 241 res_generic_po
* device instance $223 r0 *1 87.04,11.7 res_generic_po
R$223 \$149 \$151 241 res_generic_po
* device instance $224 r0 *1 93.38,11.7 res_generic_po
R$224 \$150 \$152 241 res_generic_po
* device instance $225 r0 *1 99.72,11.7 res_generic_po
R$225 \$151 \$153 241 res_generic_po
* device instance $226 r0 *1 106.06,11.7 res_generic_po
R$226 \$152 \$154 241 res_generic_po
* device instance $227 r0 *1 112.4,11.7 res_generic_po
R$227 \$153 TRIM_A 241 res_generic_po
* device instance $228 r0 *1 118.74,11.7 res_generic_po
R$228 \$154 TRIM_B 241 res_generic_po
* device instance $229 r0 *1 125.08,11.7 res_generic_po
R$229 \$156 \$157 241 res_generic_po
* device instance $230 r0 *1 131.42,11.7 res_generic_po
R$230 \$158 \$159 241 res_generic_po
* device instance $231 r0 *1 147.26,11.7 res_generic_po
R$231 \$160 \$161 48.2 res_generic_po
* device instance $232 r0 *1 149.6,11.7 res_generic_po
R$232 \$162 \$163 48.2 res_generic_po
* device instance $233 r0 *1 151.94,11.7 res_generic_po
R$233 VB \$165 48.2 res_generic_po
* device instance $234 r0 *1 154.28,11.7 res_generic_po
R$234 VA \$166 48.2 res_generic_po
* device instance $235 r0 *1 156.62,11.7 res_generic_po
R$235 \$165 \$167 48.2 res_generic_po
* device instance $236 r0 *1 158.96,11.7 res_generic_po
R$236 \$166 \$168 48.2 res_generic_po
* device instance $237 r0 *1 161.3,11.7 res_generic_po
R$237 \$167 \$169 48.2 res_generic_po
* device instance $238 r0 *1 163.64,11.7 res_generic_po
R$238 \$168 \$170 48.2 res_generic_po
* device instance $239 r0 *1 165.98,11.7 res_generic_po
R$239 \$169 \$144 48.2 res_generic_po
* device instance $240 r0 *1 168.32,11.7 res_generic_po
R$240 \$170 \$143 48.2 res_generic_po
* device instance $241 r0 *1 184.16,11.7 res_generic_po
R$241 \$171 \$172 241 res_generic_po
* device instance $242 r0 *1 190.5,11.7 res_generic_po
R$242 \$173 \$174 241 res_generic_po
* device instance $243 r0 *1 196.84,11.7 res_generic_po
R$243 VB \$175 241 res_generic_po
* device instance $244 r0 *1 203.18,11.7 res_generic_po
R$244 \$175 \$176 241 res_generic_po
* device instance $245 r0 *1 209.52,11.7 res_generic_po
R$245 \$176 \$177 241 res_generic_po
* device instance $246 r0 *1 215.86,11.7 res_generic_po
R$246 \$177 \$178 241 res_generic_po
* device instance $247 r0 *1 222.2,11.7 res_generic_po
R$247 \$178 \$179 241 res_generic_po
* device instance $248 r0 *1 228.54,11.7 res_generic_po
R$248 \$179 \$180 241 res_generic_po
* device instance $249 r0 *1 234.88,11.7 res_generic_po
R$249 \$180 VBQ 241 res_generic_po
* device instance $250 r0 *1 241.22,11.7 res_generic_po
R$250 \$181 \$182 241 res_generic_po
* device instance $251 r0 *1 247.56,11.7 res_generic_po
R$251 \$183 \$184 241 res_generic_po
.ENDS bandgap_core_routed
