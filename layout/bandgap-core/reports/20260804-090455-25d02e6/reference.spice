* layout/bandgap-core/reference.spice -- the xschem-derived LVS reference
* netlist for the bandgap core (issue #8's schematic, issue #62's LVS pair).
*
* Transcribed (modulo `.param` substitution and the klt LVS reader's own
* device-card conventions) from design/bandgap_core.sch with
* design/error_amp.sch expanded -- the live schematic, whose CORE_PARAMS
* block carries n_r2 = 54.
*
* Checked-in netlist evidence for that same parameter set:
*   sim/output-voltage-tc/netlist-snapshots/20260803-115356-7759435.spice
* (`.param n_r2=54`; byte-identical to the earlier
* .../20260803-102002-32194bc.spice). Both predate the DR-002 trim
* parameters (n_r2_trim / r_lseg_trim), which are no-ops at code 0 and so do
* not change the topology or the values below.
*
* PROVENANCE CORRECTION: an earlier revision of this file cited
* sim/output-voltage-tc/netlist-snapshots/20260803-142220-b24b404.spice as
* its source. That snapshot carries `.param n_r2=55` -- the candidate commit
* 297073f (issue #57) records as REJECTED (it loses the bandgap operating
* point above ~124 degC at ff/2.97 V and fs/2.97 V). The transcribed values
* here were always the n_r2=54 design values; only the citation was wrong.
*
* INPUT-PAIR CORRECTION: an earlier revision of this file transcribed the
* amp's differential inputs the wrong way round (`MMP1 ... VA` / `MMP2 ... VB`).
* The schematic says the opposite, and the mapping is worth writing down
* because it survives no relabeling -- D1 and D2 are distinguishable in the
* graph (D1 drives MMN3 -> GDRV, D2 drives MMN4 -> PN), so a VA<->VB rename
* would have to move R1 and Q1's emitter too, and those are already correct:
*   design/error_amp.sym    VINP pin box at symbol-relative (-50, -20),
*                           VINN at (-50, +20); header: "VINP non-inverting
*                           input (AOUT rises when VINP rises)".
*   design/bandgap_core.sch XAMP instantiated at 900 -600 rot 0 flip 0, so
*                           VINP lands on (850, -620) = `ampp lab=VB` and
*                           VINN on (850, -580) = `ampn lab=VA`.
*   design/error_amp.sch    MP1 gate = VINP (mp1g), MP2 gate = VINN (mp2g);
*                           MP1 drain = D1, MP2 drain = D2.
*   => flattened: MMP1 D1 VB TAIL VDD  and  MMP2 D2 VA TAIL VDD.
* The checked-in snapshot cited below agrees:
*   `XAMP VB VA GDRV TAIL VDD VSS error_amp` against
*   `.subckt error_amp VINP VINN AOUT ITAIL VDD VSS`.
* VINP = VB is also what makes the loop negative-feedback: VB is the
* higher-impedance leg (R1 + r_Q2 vs r_Q1), so it moves more per volt of
* VOUT. The previous transcription described a positive-feedback amplifier.
* The rest of the VA/VB assignments were, and remain, as the schematic has
* them: R2A on VA (`r2am lab=VA`), R2B on VB (`r2bm lab=VB`), R1's head on
* VB (`r1p lab=VB`) with its tail on VBQ, Q1's emitter on VA (`q1e lab=VA`)
* and Q2's emitter on VBQ (`q2e lab=VBQ`).
*
* Parameters (design/bandgap_core.sch CORE_PARAMS, design/error_amp.sch):
*   n_pnp_ctat = n_pnp_ptat = 8      r_w = 1     r_lseg = 5
*   n_r1 = 7    n_r2 = 54            n_r2_trim = 0 (untrimmed, code 0)
*   m_out = m_ampbias = 2
*   amp_m_in = 16   amp_m_nmirr = 4   amp_m_pmirr = 8   amp_m_cc = 16
*
* This file is the *schematic side* of LVS. It is deliberately NOT derived
* from the layout: the whole point of the comparison is that the two were
* produced independently. Device multiplicity is carried as `m=` on each
* card (the layout draws `m` physical instances of each), and R2A/R2B carry
* their untrimmed length `r_lseg * n_r2 = 270u`; the trim ladder's taps are
* a metal option (DR-002) that does not change code-0 topology.
*
* The `res_high_po` model name on the R cards below is the schematic's own
* device (design/bandgap_core.sch instantiates sky130_fd_pr__res_high_po on
* every leg). An earlier revision named `res_generic_po` instead, because
* that was the only flavour `klt gen res_array` could draw; the reference has
* no business tracking the layout's tooling limits, and since
* 2AMLogic/klayout-tools#463 merged there is no limit to track.
*
* Resistor values follow the schematic's own unit model, stated at
* design/bandgap_core.sch line 188: a res_high_po segment of width r_w and
* length L has R ~ 380 + 325*L ohm. The 380 ohm head is per *device*, i.e.
* per leg -- design/bandgap_core.sch line 191 flags the consequence
* explicitly ("each leg has its own 380 ohm head resistance, so K != n_r2/n_r1
* exactly"). R2A/R2B and R1 are each one res_high_po device, so each carries
* exactly one head:
*   R2A = R2B = 380 + 325*270 = 88130 ohm      (L = r_lseg*n_r2  = 270 um)
*   R1        = 380 + 325*35  = 11755 ohm      (L = r_lseg*n_r1  =  35 um)
*   K = R2/R1 = 88130/11755   = 7.4972         (not n_r2/n_r1 = 7.7143)
*
* KNOWN LAYOUT-SIDE GAPS, disclosed here rather than modelled away:
*   - The amp's output and the core mirror's gate drive are ONE net in the
*     schematic (`XAMP VB VA GDRV TAIL VDD VSS error_amp` ties error_amp's
*     AOUT opin straight to bandgap_core's GDRV iopin); this file therefore
*     names that single node `GDRV` throughout, with no device between the
*     amp drain and the mirror gates. A previous revision of this file
*     bridged the layout's then-separate `AOUT`/`GDRV` pins with a 0-ohm
*     `RGDRV AOUT GDRV 0` card, which made the reference a 17-device netlist
*     with a device the schematic does not contain, purely to accommodate the
*     layout. That is removed, and the layout now draws the node as one:
*     the reference states the schematic, and the record states the layout.
*   - `VOUT` likewise joins MPOUT's drain and both R2A/R2B tops here, as in
*     the schematic. Whether the layout draws that join is stated in the
*     routed record's own coverage table, not accommodated here.
*   - The layout's device *bulk* terminals for every nfet, every poly
*     resistor and both PNP collectors are extracted onto sky130's
*     deck-synthesized `vsubs` global, not onto the drawn `VSS` this file
*     names, because the curated extraction deck registers an empty
*     `nfet_body` region for them and `connect_global`s it. No drawn shape
*     can join that net. Stated here, and declared to `klt lvs` through a
*     `hints.same_nets` entry by the flow -- NOT worked around by renaming
*     the schematic's ground node.
*
* Terminal orders follow KLayout's SPICE reader defaults for each device
* class the sky130 extraction deck registers:
*   M<name> D G S B <model>            (nfet/pfet)
*   Q<name> C B E <model>              (pnp)
*   R<name> A B <value> <model>        (res_high_po)

.subckt bandgap_core VOUT GDRV VDD VSS
* ---- core PMOS mirror (MPOUT / MPAMP), W=8 L=2, mult=2 each -------------
MMPOUT VOUT GDRV VDD VDD pfet L=2U W=8U m=2
MMPAMP TAIL GDRV VDD VDD pfet L=2U W=8U m=2
* ---- error amplifier (design/error_amp.sch), flattened -----------------
* The amp's output node IS the core's gate-drive node (schematic AOUT/GDRV).
* MP1's gate is VINP = VB; MP2's gate is VINN = VA (see INPUT-PAIR CORRECTION).
MMP1  D1   VB   TAIL VDD pfet L=10U W=20U m=16
MMP2  D2   VA   TAIL VDD pfet L=10U W=20U m=16
MMN1  D1   D1   VSS  VSS nfet L=20U W=8U  m=4
MMN2  D2   D2   VSS  VSS nfet L=20U W=8U  m=4
MMN3  GDRV D1   VSS  VSS nfet L=20U W=8U  m=4
MMN4  PN   D2   VSS  VSS nfet L=20U W=8U  m=4
MMP4  GDRV PN   VDD  VDD pfet L=20U W=6U  m=8
MMP3  PN   PN   VDD  VDD pfet L=20U W=6U  m=8
MMCC  VDD  GDRV VDD  VDD pfet L=20U W=30U m=16
* ---- divider legs: R2A/R2B, W=1 L=270 (n_r2=54 x r_lseg=5) -------------
* 380 + 325*270 = 88130 (see the unit-model note above)
RR2A VA  VOUT 88130 res_high_po
RR2B VB  VOUT 88130 res_high_po
* ---- dVBE leg: R1, W=1 L=35 (n_r1=7 x r_lseg=5) ------------------------
* 380 + 325*35 = 11755
RR1  VBQ VB   11755 res_high_po
* ---- PNP pair, diode-connected (base and collector to VSS) -------------
QQ1 VSS VSS VA  pnp m=8
QQ2 VSS VSS VBQ pnp m=8
.ends bandgap_core
