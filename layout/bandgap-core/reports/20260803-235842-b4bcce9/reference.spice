* layout/bandgap-core/reference.spice -- the xschem-derived LVS reference
* netlist for the bandgap core (issue #8's schematic, issue #62's LVS pair).
*
* Transcribed (modulo `.param` substitution and the klt LVS reader's own
* device-card conventions) from design/bandgap_core.sch with
* design/error_amp.sch expanded -- the live schematic, whose CORE_PARAMS
* block carries n_r2 = 54.
*
* Checked-in netlist evidence for that same parameter set:
*   sim/output-voltage-tc/netlist-snapshots/20260803-115356-7759435.spice
* (`.param n_r2=54`; byte-identical to the earlier
* .../20260803-102002-32194bc.spice). Both predate the DR-002 trim
* parameters (n_r2_trim / r_lseg_trim), which are no-ops at code 0 and so do
* not change the topology or the values below.
*
* PROVENANCE CORRECTION: an earlier revision of this file cited
* sim/output-voltage-tc/netlist-snapshots/20260803-142220-b24b404.spice as
* its source. That snapshot carries `.param n_r2=55` -- the candidate commit
* 297073f (issue #57) records as REJECTED (it loses the bandgap operating
* point above ~124 degC at ff/2.97 V and fs/2.97 V). The transcribed values
* here were always the n_r2=54 design values; only the citation was wrong.
*
* Parameters (design/bandgap_core.sch CORE_PARAMS, design/error_amp.sch):
*   n_pnp_ctat = n_pnp_ptat = 8      r_w = 1     r_lseg = 5
*   n_r1 = 7    n_r2 = 54            n_r2_trim = 0 (untrimmed, code 0)
*   m_out = m_ampbias = 2
*   amp_m_in = 16   amp_m_nmirr = 4   amp_m_pmirr = 8   amp_m_cc = 16
*
* This file is the *schematic side* of LVS. It is deliberately NOT derived
* from the layout: the whole point of the comparison is that the two were
* produced independently. Device multiplicity is carried as `m=` on each
* card (the layout draws `m` physical instances of each), and R2A/R2B carry
* their untrimmed length `r_lseg * n_r2 = 270u`; the trim ladder's taps are
* a metal option (DR-002) that does not change code-0 topology.
*
* Resistor values follow the schematic's own unit model, stated at
* design/bandgap_core.sch line 188: a res_high_po segment of width r_w and
* length L has R ~ 380 + 325*L ohm. The 380 ohm head is per *device*, i.e.
* per leg -- design/bandgap_core.sch line 191 flags the consequence
* explicitly ("each leg has its own 380 ohm head resistance, so K != n_r2/n_r1
* exactly"). R2A/R2B and R1 are each one res_high_po device, so each carries
* exactly one head:
*   R2A = R2B = 380 + 325*270 = 88130 ohm      (L = r_lseg*n_r2  = 270 um)
*   R1        = 380 + 325*35  = 11755 ohm      (L = r_lseg*n_r1  =  35 um)
*   K = R2/R1 = 88130/11755   = 7.4972         (not n_r2/n_r1 = 7.7143)
*
* KNOWN LAYOUT-SIDE GAPS, disclosed here rather than modelled away:
*   - The amp's output and the core mirror's gate drive are ONE net in the
*     schematic (`XAMP VB VA GDRV TAIL VDD VSS error_amp` ties error_amp's
*     AOUT opin straight to bandgap_core's GDRV iopin); this file therefore
*     names that single node `GDRV` throughout, with no device between the
*     amp drain and the mirror gates. The current layout leaves them as two
*     separate, unrouted labelled pins (`AOUT` on amp_pmirr, `GDRV` on
*     core_mirror) -- see the routed record's schematic-inter-block-net
*     table. A previous revision of this file bridged them with a 0-ohm
*     `RGDRV AOUT GDRV 0` card, which made the reference a 17-device netlist
*     with a device the schematic does not contain, purely to accommodate the
*     layout. That is removed: the reference states the schematic, and the
*     record states the layout's gap.
*   - `VOUT` likewise joins MPOUT's drain and both R2A/R2B tops here, as in
*     the schematic; in the layout `VOUT` is a labelled pin on core_mirror
*     only and is not yet routed to the ladder (2AMLogic/klayout-tools#433).
*     Not accommodated here either.
*
* Terminal orders follow KLayout's SPICE reader defaults for each device
* class the sky130 extraction deck registers:
*   M<name> D G S B <model>            (nfet/pfet)
*   Q<name> C B E <model>              (pnp)
*   R<name> A B <value> <model>        (res_generic_po)

.subckt bandgap_core VOUT GDRV VDD VSS
* ---- core PMOS mirror (MPOUT / MPAMP), W=8 L=2, mult=2 each -------------
MMPOUT VOUT GDRV VDD VDD pfet L=2U W=8U m=2
MMPAMP TAIL GDRV VDD VDD pfet L=2U W=8U m=2
* ---- error amplifier (design/error_amp.sch), flattened -----------------
* The amp's output node IS the core's gate-drive node (schematic AOUT/GDRV).
MMP1  D1   VA   TAIL VDD pfet L=10U W=20U m=16
MMP2  D2   VB   TAIL VDD pfet L=10U W=20U m=16
MMN1  D1   D1   VSS  VSS nfet L=20U W=8U  m=4
MMN2  D2   D2   VSS  VSS nfet L=20U W=8U  m=4
MMN3  GDRV D1   VSS  VSS nfet L=20U W=8U  m=4
MMN4  PN   D2   VSS  VSS nfet L=20U W=8U  m=4
MMP4  GDRV PN   VDD  VDD pfet L=20U W=6U  m=8
MMP3  PN   PN   VDD  VDD pfet L=20U W=6U  m=8
MMCC  VDD  GDRV VDD  VDD pfet L=20U W=30U m=16
* ---- divider legs: R2A/R2B, W=1 L=270 (n_r2=54 x r_lseg=5) -------------
* 380 + 325*270 = 88130 (see the unit-model note above)
RR2A VA  VOUT 88130 res_generic_po
RR2B VB  VOUT 88130 res_generic_po
* ---- dVBE leg: R1, W=1 L=35 (n_r1=7 x r_lseg=5) ------------------------
* 380 + 325*35 = 11755
RR1  VBQ VB   11755 res_generic_po
* ---- PNP pair, diode-connected (base and collector to VSS) -------------
QQ1 VSS VSS VA  pnp m=8
QQ2 VSS VSS VBQ pnp m=8
.ends bandgap_core
