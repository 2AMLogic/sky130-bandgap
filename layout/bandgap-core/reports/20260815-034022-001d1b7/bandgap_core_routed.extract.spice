* extracted by klt extract --deck sky130

* cell bandgap_core_routed
* pin D1
* pin D2
* pin GDRV
* pin PN
* pin TAIL
* pin VA
* pin VB
* pin VBQ
* pin VDD
* pin VOUT
* pin VSS
.SUBCKT bandgap_core_routed D1 D2 GDRV PN TAIL VA VB VBQ VDD VOUT VSS
* device instance $1 r0 *1 171.11,52.67 nfet
M$1 VSS D1 D1 VSS nfet L=20U W=8U AS=3.36P AD=3.36P PS=16.84U PD=16.84U
* device instance $2 r0 *1 192.35,52.67 nfet
M$2 VSS D2 D2 VSS nfet L=20U W=8U AS=3.36P AD=3.36P PS=16.84U PD=16.84U
* device instance $3 r0 *1 213.59,52.67 nfet
M$3 VSS D1 D1 VSS nfet L=20U W=8U AS=3.36P AD=3.36P PS=16.84U PD=16.84U
* device instance $4 r0 *1 234.83,52.67 nfet
M$4 VSS D2 D2 VSS nfet L=20U W=8U AS=3.36P AD=3.36P PS=16.84U PD=16.84U
* device instance $5 r0 *1 171.11,61.49 nfet
M$5 VSS D2 D2 VSS nfet L=20U W=8U AS=3.36P AD=3.36P PS=16.84U PD=16.84U
* device instance $6 r0 *1 192.35,61.49 nfet
M$6 VSS D1 D1 VSS nfet L=20U W=8U AS=3.36P AD=3.36P PS=16.84U PD=16.84U
* device instance $7 r0 *1 213.59,61.49 nfet
M$7 VSS D2 D2 VSS nfet L=20U W=8U AS=3.36P AD=3.36P PS=16.84U PD=16.84U
* device instance $8 r0 *1 234.83,61.49 nfet
M$8 VSS D1 D1 VSS nfet L=20U W=8U AS=3.36P AD=3.36P PS=16.84U PD=16.84U
* device instance $9 r0 *1 199,105.9 nfet
M$9 VSS D2 PN VSS nfet L=20U W=8U AS=3.36P AD=3.36P PS=16.84U PD=16.84U
* device instance $10 r0 *1 220.24,105.9 nfet
M$10 VSS D1 GDRV VSS nfet L=20U W=8U AS=3.36P AD=3.36P PS=16.84U PD=16.84U
* device instance $11 r0 *1 241.48,105.9 nfet
M$11 VSS D2 PN VSS nfet L=20U W=8U AS=3.36P AD=3.36P PS=16.84U PD=16.84U
* device instance $12 r0 *1 262.72,105.9 nfet
M$12 VSS D1 GDRV VSS nfet L=20U W=8U AS=3.36P AD=3.36P PS=16.84U PD=16.84U
* device instance $13 r0 *1 199,114.72 nfet
M$13 VSS D1 GDRV VSS nfet L=20U W=8U AS=3.36P AD=3.36P PS=16.84U PD=16.84U
* device instance $14 r0 *1 220.24,114.72 nfet
M$14 VSS D2 PN VSS nfet L=20U W=8U AS=3.36P AD=3.36P PS=16.84U PD=16.84U
* device instance $15 r0 *1 241.48,114.72 nfet
M$15 VSS D1 GDRV VSS nfet L=20U W=8U AS=3.36P AD=3.36P PS=16.84U PD=16.84U
* device instance $16 r0 *1 262.72,114.72 nfet
M$16 VSS D2 PN VSS nfet L=20U W=8U AS=3.36P AD=3.36P PS=16.84U PD=16.84U
* device instance $17 r0 *1 58.6,46.67 pfet
M$17 D2 VA TAIL VDD pfet L=10U W=20U AS=8.4P AD=8.4P PS=40.84U PD=40.84U
* device instance $18 r0 *1 69.84,46.67 pfet
M$18 D1 VB TAIL VDD pfet L=10U W=20U AS=8.4P AD=8.4P PS=40.84U PD=40.84U
* device instance $19 r0 *1 81.08,46.67 pfet
M$19 D2 VA TAIL VDD pfet L=10U W=20U AS=8.4P AD=8.4P PS=40.84U PD=40.84U
* device instance $20 r0 *1 92.32,46.67 pfet
M$20 D1 VB TAIL VDD pfet L=10U W=20U AS=8.4P AD=8.4P PS=40.84U PD=40.84U
* device instance $21 r0 *1 103.56,46.67 pfet
M$21 D2 VA TAIL VDD pfet L=10U W=20U AS=8.4P AD=8.4P PS=40.84U PD=40.84U
* device instance $22 r0 *1 114.8,46.67 pfet
M$22 D1 VB TAIL VDD pfet L=10U W=20U AS=8.4P AD=8.4P PS=40.84U PD=40.84U
* device instance $23 r0 *1 126.04,46.67 pfet
M$23 D2 VA TAIL VDD pfet L=10U W=20U AS=8.4P AD=8.4P PS=40.84U PD=40.84U
* device instance $24 r0 *1 137.28,46.67 pfet
M$24 D1 VB TAIL VDD pfet L=10U W=20U AS=8.4P AD=8.4P PS=40.84U PD=40.84U
* device instance $25 r0 *1 30.38,61.49 pfet
M$25 TAIL GDRV VDD VDD pfet L=2U W=8U AS=3.36P AD=3.36P PS=16.84U PD=16.84U
* device instance $26 r0 *1 30.38,52.67 pfet
M$26 VOUT GDRV VDD VDD pfet L=2U W=8U AS=3.36P AD=3.36P PS=16.84U PD=16.84U
* device instance $27 r0 *1 33.62,61.49 pfet
M$27 VOUT GDRV VDD VDD pfet L=2U W=8U AS=3.36P AD=3.36P PS=16.84U PD=16.84U
* device instance $28 r0 *1 33.62,52.67 pfet
M$28 TAIL GDRV VDD VDD pfet L=2U W=8U AS=3.36P AD=3.36P PS=16.84U PD=16.84U
* device instance $29 r0 *1 58.6,67.49 pfet
M$29 D1 VB TAIL VDD pfet L=10U W=20U AS=8.4P AD=8.4P PS=40.84U PD=40.84U
* device instance $30 r0 *1 69.84,67.49 pfet
M$30 D2 VA TAIL VDD pfet L=10U W=20U AS=8.4P AD=8.4P PS=40.84U PD=40.84U
* device instance $31 r0 *1 81.08,67.49 pfet
M$31 D1 VB TAIL VDD pfet L=10U W=20U AS=8.4P AD=8.4P PS=40.84U PD=40.84U
* device instance $32 r0 *1 92.32,67.49 pfet
M$32 D2 VA TAIL VDD pfet L=10U W=20U AS=8.4P AD=8.4P PS=40.84U PD=40.84U
* device instance $33 r0 *1 103.56,67.49 pfet
M$33 D1 VB TAIL VDD pfet L=10U W=20U AS=8.4P AD=8.4P PS=40.84U PD=40.84U
* device instance $34 r0 *1 114.8,67.49 pfet
M$34 D2 VA TAIL VDD pfet L=10U W=20U AS=8.4P AD=8.4P PS=40.84U PD=40.84U
* device instance $35 r0 *1 126.04,67.49 pfet
M$35 D1 VB TAIL VDD pfet L=10U W=20U AS=8.4P AD=8.4P PS=40.84U PD=40.84U
* device instance $36 r0 *1 137.28,67.49 pfet
M$36 D2 VA TAIL VDD pfet L=10U W=20U AS=8.4P AD=8.4P PS=40.84U PD=40.84U
* device instance $37 r0 *1 11.49,113.72 pfet
M$37 GDRV PN VDD VDD pfet L=20U W=6U AS=2.52P AD=2.52P PS=12.84U PD=12.84U
* device instance $38 r0 *1 11.49,106.9 pfet
M$38 PN PN VDD VDD pfet L=20U W=6U AS=2.52P AD=2.52P PS=12.84U PD=12.84U
* device instance $39 r0 *1 32.73,106.9 pfet
M$39 GDRV PN VDD VDD pfet L=20U W=6U AS=2.52P AD=2.52P PS=12.84U PD=12.84U
* device instance $40 r0 *1 32.73,113.72 pfet
M$40 PN PN VDD VDD pfet L=20U W=6U AS=2.52P AD=2.52P PS=12.84U PD=12.84U
* device instance $41 r0 *1 53.97,113.72 pfet
M$41 GDRV PN VDD VDD pfet L=20U W=6U AS=2.52P AD=2.52P PS=12.84U PD=12.84U
* device instance $42 r0 *1 53.97,106.9 pfet
M$42 PN PN VDD VDD pfet L=20U W=6U AS=2.52P AD=2.52P PS=12.84U PD=12.84U
* device instance $43 r0 *1 75.21,113.72 pfet
M$43 PN PN VDD VDD pfet L=20U W=6U AS=2.52P AD=2.52P PS=12.84U PD=12.84U
* device instance $44 r0 *1 75.21,106.9 pfet
M$44 GDRV PN VDD VDD pfet L=20U W=6U AS=2.52P AD=2.52P PS=12.84U PD=12.84U
* device instance $45 r0 *1 96.45,113.72 pfet
M$45 GDRV PN VDD VDD pfet L=20U W=6U AS=2.52P AD=2.52P PS=12.84U PD=12.84U
* device instance $46 r0 *1 96.45,106.9 pfet
M$46 PN PN VDD VDD pfet L=20U W=6U AS=2.52P AD=2.52P PS=12.84U PD=12.84U
* device instance $47 r0 *1 117.69,106.9 pfet
M$47 GDRV PN VDD VDD pfet L=20U W=6U AS=2.52P AD=2.52P PS=12.84U PD=12.84U
* device instance $48 r0 *1 117.69,113.72 pfet
M$48 PN PN VDD VDD pfet L=20U W=6U AS=2.52P AD=2.52P PS=12.84U PD=12.84U
* device instance $49 r0 *1 138.93,106.9 pfet
M$49 PN PN VDD VDD pfet L=20U W=6U AS=2.52P AD=2.52P PS=12.84U PD=12.84U
* device instance $50 r0 *1 138.93,113.72 pfet
M$50 GDRV PN VDD VDD pfet L=20U W=6U AS=2.52P AD=2.52P PS=12.84U PD=12.84U
* device instance $51 r0 *1 160.17,113.72 pfet
M$51 PN PN VDD VDD pfet L=20U W=6U AS=2.52P AD=2.52P PS=12.84U PD=12.84U
* device instance $52 r0 *1 160.17,106.9 pfet
M$52 GDRV PN VDD VDD pfet L=20U W=6U AS=2.52P AD=2.52P PS=12.84U PD=12.84U
* device instance $53 r0 *1 62.69,158.13 pfet
M$53 VDD GDRV VDD VDD pfet L=20U W=30U AS=12.6P AD=12.6P PS=60.84U PD=60.84U
* device instance $54 r0 *1 83.93,158.13 pfet
M$54 VDD GDRV VDD VDD pfet L=20U W=30U AS=12.6P AD=12.6P PS=60.84U PD=60.84U
* device instance $55 r0 *1 105.17,158.13 pfet
M$55 VDD GDRV VDD VDD pfet L=20U W=30U AS=12.6P AD=12.6P PS=60.84U PD=60.84U
* device instance $56 r0 *1 126.41,158.13 pfet
M$56 VDD GDRV VDD VDD pfet L=20U W=30U AS=12.6P AD=12.6P PS=60.84U PD=60.84U
* device instance $57 r0 *1 147.65,158.13 pfet
M$57 VDD GDRV VDD VDD pfet L=20U W=30U AS=12.6P AD=12.6P PS=60.84U PD=60.84U
* device instance $58 r0 *1 168.89,158.13 pfet
M$58 VDD GDRV VDD VDD pfet L=20U W=30U AS=12.6P AD=12.6P PS=60.84U PD=60.84U
* device instance $59 r0 *1 190.13,158.13 pfet
M$59 VDD GDRV VDD VDD pfet L=20U W=30U AS=12.6P AD=12.6P PS=60.84U PD=60.84U
* device instance $60 r0 *1 211.37,158.13 pfet
M$60 VDD GDRV VDD VDD pfet L=20U W=30U AS=12.6P AD=12.6P PS=60.84U PD=60.84U
* device instance $61 r0 *1 62.69,188.95 pfet
M$61 VDD GDRV VDD VDD pfet L=20U W=30U AS=12.6P AD=12.6P PS=60.84U PD=60.84U
* device instance $62 r0 *1 83.93,188.95 pfet
M$62 VDD GDRV VDD VDD pfet L=20U W=30U AS=12.6P AD=12.6P PS=60.84U PD=60.84U
* device instance $63 r0 *1 105.17,188.95 pfet
M$63 VDD GDRV VDD VDD pfet L=20U W=30U AS=12.6P AD=12.6P PS=60.84U PD=60.84U
* device instance $64 r0 *1 126.41,188.95 pfet
M$64 VDD GDRV VDD VDD pfet L=20U W=30U AS=12.6P AD=12.6P PS=60.84U PD=60.84U
* device instance $65 r0 *1 147.65,188.95 pfet
M$65 VDD GDRV VDD VDD pfet L=20U W=30U AS=12.6P AD=12.6P PS=60.84U PD=60.84U
* device instance $66 r0 *1 168.89,188.95 pfet
M$66 VDD GDRV VDD VDD pfet L=20U W=30U AS=12.6P AD=12.6P PS=60.84U PD=60.84U
* device instance $67 r0 *1 190.13,188.95 pfet
M$67 VDD GDRV VDD VDD pfet L=20U W=30U AS=12.6P AD=12.6P PS=60.84U PD=60.84U
* device instance $68 r0 *1 211.37,188.95 pfet
M$68 VDD GDRV VDD VDD pfet L=20U W=30U AS=12.6P AD=12.6P PS=60.84U PD=60.84U
* device instance $69 r0 *1 3.94,1.31 pnp
Q$69 VSS VSS VA pnp AE=0.4624P PE=2.72U AB=0.7744P PB=3.52U AC=0.7744P PC=3.52U
+ NE=1
* device instance $70 r0 *1 5.84,1.31 pnp
Q$70 VSS VSS VA pnp AE=0.4624P PE=2.72U AB=0.7744P PB=3.52U AC=0.7744P PC=3.52U
+ NE=1
* device instance $71 r0 *1 7.74,1.31 pnp
Q$71 VSS VSS VA pnp AE=0.4624P PE=2.72U AB=0.7744P PB=3.52U AC=0.7744P PC=3.52U
+ NE=1
* device instance $72 r0 *1 9.64,1.31 pnp
Q$72 VSS VSS VA pnp AE=0.4624P PE=2.72U AB=0.7744P PB=3.52U AC=0.7744P PC=3.52U
+ NE=1
* device instance $73 r0 *1 3.94,2.39 pnp
Q$73 VSS VSS VA pnp AE=0.4624P PE=2.72U AB=0.7744P PB=3.52U AC=0.7744P PC=3.52U
+ NE=1
* device instance $74 r0 *1 5.84,2.39 pnp
Q$74 VSS VSS VA pnp AE=0.4624P PE=2.72U AB=0.7744P PB=3.52U AC=0.7744P PC=3.52U
+ NE=1
* device instance $75 r0 *1 7.74,2.39 pnp
Q$75 VSS VSS VA pnp AE=0.4624P PE=2.72U AB=0.7744P PB=3.52U AC=0.7744P PC=3.52U
+ NE=1
* device instance $76 r0 *1 9.64,2.39 pnp
Q$76 VSS VSS VA pnp AE=0.4624P PE=2.72U AB=0.7744P PB=3.52U AC=0.7744P PC=3.52U
+ NE=1
* device instance $77 r0 *1 251.36,2.67 pnp
Q$77 VSS VSS VBQ pnp AE=11.56P PE=13.6U AB=12.96P PB=14.4U AC=12.96P PC=14.4U
+ NE=1
* device instance $78 r0 *1 255.98,2.67 pnp
Q$78 VSS VSS VBQ pnp AE=11.56P PE=13.6U AB=12.96P PB=14.4U AC=12.96P PC=14.4U
+ NE=1
* device instance $79 r0 *1 260.6,2.67 pnp
Q$79 VSS VSS VBQ pnp AE=11.56P PE=13.6U AB=12.96P PB=14.4U AC=12.96P PC=14.4U
+ NE=1
* device instance $80 r0 *1 265.22,2.67 pnp
Q$80 VSS VSS VBQ pnp AE=11.56P PE=13.6U AB=12.96P PB=14.4U AC=12.96P PC=14.4U
+ NE=1
* device instance $81 r0 *1 251.36,6.47 pnp
Q$81 VSS VSS VBQ pnp AE=11.56P PE=13.6U AB=12.96P PB=14.4U AC=12.96P PC=14.4U
+ NE=1
* device instance $82 r0 *1 255.98,6.47 pnp
Q$82 VSS VSS VBQ pnp AE=11.56P PE=13.6U AB=12.96P PB=14.4U AC=12.96P PC=14.4U
+ NE=1
* device instance $83 r0 *1 260.6,6.47 pnp
Q$83 VSS VSS VBQ pnp AE=11.56P PE=13.6U AB=12.96P PB=14.4U AC=12.96P PC=14.4U
+ NE=1
* device instance $84 r0 *1 265.22,6.47 pnp
Q$84 VSS VSS VBQ pnp AE=11.56P PE=13.6U AB=12.96P PB=14.4U AC=12.96P PC=14.4U
+ NE=1
* device instance $85 r0 *1 45.27,0.5 res_high_po
R$85 VOUT \$6 VSS 2003.841367 res_high_po
* device instance $86 r0 *1 51.61,0.5 res_high_po
R$86 VOUT \$7 VSS 2003.841367 res_high_po
* device instance $87 r0 *1 57.95,0.5 res_high_po
R$87 \$6 \$8 VSS 2003.841367 res_high_po
* device instance $88 r0 *1 64.29,0.5 res_high_po
R$88 \$7 \$9 VSS 2003.841367 res_high_po
* device instance $89 r0 *1 70.63,0.5 res_high_po
R$89 \$8 \$10 VSS 2003.841367 res_high_po
* device instance $90 r0 *1 76.97,0.5 res_high_po
R$90 \$9 \$11 VSS 2003.841367 res_high_po
* device instance $91 r0 *1 83.31,0.5 res_high_po
R$91 \$10 \$12 VSS 2003.841367 res_high_po
* device instance $92 r0 *1 89.65,0.5 res_high_po
R$92 \$11 \$13 VSS 2003.841367 res_high_po
* device instance $93 r0 *1 95.99,0.5 res_high_po
R$93 \$12 \$14 VSS 2003.841367 res_high_po
* device instance $94 r0 *1 102.33,0.5 res_high_po
R$94 \$13 \$16 VSS 2003.841367 res_high_po
* device instance $95 r0 *1 45.27,3.3 res_high_po
R$95 \$20 \$35 VSS 2003.841367 res_high_po
* device instance $96 r0 *1 45.27,1.9 res_high_po
R$96 \$21 \$22 VSS 2003.841367 res_high_po
* device instance $97 r0 *1 51.61,1.9 res_high_po
R$97 \$20 \$23 VSS 2003.841367 res_high_po
* device instance $98 r0 *1 51.61,3.3 res_high_po
R$98 \$21 \$36 VSS 2003.841367 res_high_po
* device instance $99 r0 *1 57.95,3.3 res_high_po
R$99 \$35 \$37 VSS 2003.841367 res_high_po
* device instance $100 r0 *1 57.95,1.9 res_high_po
R$100 \$22 \$24 VSS 2003.841367 res_high_po
* device instance $101 r0 *1 64.29,3.3 res_high_po
R$101 \$36 \$38 VSS 2003.841367 res_high_po
* device instance $102 r0 *1 64.29,1.9 res_high_po
R$102 \$23 \$25 VSS 2003.841367 res_high_po
* device instance $103 r0 *1 70.63,1.9 res_high_po
R$103 \$24 \$26 VSS 2003.841367 res_high_po
* device instance $104 r0 *1 70.63,3.3 res_high_po
R$104 \$37 \$39 VSS 2003.841367 res_high_po
* device instance $105 r0 *1 76.97,3.3 res_high_po
R$105 \$38 \$40 VSS 2003.841367 res_high_po
* device instance $106 r0 *1 76.97,1.9 res_high_po
R$106 \$25 \$27 VSS 2003.841367 res_high_po
* device instance $107 r0 *1 83.31,1.9 res_high_po
R$107 \$26 \$28 VSS 2003.841367 res_high_po
* device instance $108 r0 *1 83.31,3.3 res_high_po
R$108 \$39 \$41 VSS 2003.841367 res_high_po
* device instance $109 r0 *1 89.65,1.9 res_high_po
R$109 \$27 \$29 VSS 2003.841367 res_high_po
* device instance $110 r0 *1 89.65,3.3 res_high_po
R$110 \$40 \$42 VSS 2003.841367 res_high_po
* device instance $111 r0 *1 95.99,1.9 res_high_po
R$111 \$28 \$16 VSS 2003.841367 res_high_po
* device instance $112 r0 *1 95.99,3.3 res_high_po
R$112 \$41 \$43 VSS 2003.841367 res_high_po
* device instance $113 r0 *1 102.33,3.3 res_high_po
R$113 \$42 \$44 VSS 2003.841367 res_high_po
* device instance $114 r0 *1 102.33,1.9 res_high_po
R$114 \$29 \$14 VSS 2003.841367 res_high_po
* device instance $115 r0 *1 45.27,4.7 res_high_po
R$115 \$46 \$47 VSS 2003.841367 res_high_po
* device instance $116 r0 *1 51.61,4.7 res_high_po
R$116 \$45 \$48 VSS 2003.841367 res_high_po
* device instance $117 r0 *1 57.95,4.7 res_high_po
R$117 \$47 \$49 VSS 2003.841367 res_high_po
* device instance $118 r0 *1 64.29,4.7 res_high_po
R$118 \$48 \$50 VSS 2003.841367 res_high_po
* device instance $119 r0 *1 70.63,4.7 res_high_po
R$119 \$49 \$51 VSS 2003.841367 res_high_po
* device instance $120 r0 *1 76.97,4.7 res_high_po
R$120 \$50 \$52 VSS 2003.841367 res_high_po
* device instance $121 r0 *1 83.31,4.7 res_high_po
R$121 \$51 \$53 VSS 2003.841367 res_high_po
* device instance $122 r0 *1 89.65,4.7 res_high_po
R$122 \$52 \$54 VSS 2003.841367 res_high_po
* device instance $123 r0 *1 95.99,4.7 res_high_po
R$123 \$53 \$44 VSS 2003.841367 res_high_po
* device instance $124 r0 *1 102.33,4.7 res_high_po
R$124 \$54 \$43 VSS 2003.841367 res_high_po
* device instance $125 r0 *1 45.27,6.1 res_high_po
R$125 \$45 \$55 VSS 2003.841367 res_high_po
* device instance $126 r0 *1 51.61,6.1 res_high_po
R$126 \$46 \$56 VSS 2003.841367 res_high_po
* device instance $127 r0 *1 57.95,6.1 res_high_po
R$127 \$55 \$57 VSS 2003.841367 res_high_po
* device instance $128 r0 *1 64.29,6.1 res_high_po
R$128 \$56 \$58 VSS 2003.841367 res_high_po
* device instance $129 r0 *1 70.63,6.1 res_high_po
R$129 \$57 \$59 VSS 2003.841367 res_high_po
* device instance $130 r0 *1 76.97,6.1 res_high_po
R$130 \$58 \$60 VSS 2003.841367 res_high_po
* device instance $131 r0 *1 83.31,6.1 res_high_po
R$131 \$59 \$61 VSS 2003.841367 res_high_po
* device instance $132 r0 *1 89.65,6.1 res_high_po
R$132 \$60 \$62 VSS 2003.841367 res_high_po
* device instance $133 r0 *1 95.99,6.1 res_high_po
R$133 \$61 \$63 VSS 2003.841367 res_high_po
* device instance $134 r0 *1 102.33,6.1 res_high_po
R$134 \$62 \$64 VSS 2003.841367 res_high_po
* device instance $135 r0 *1 45.27,7.5 res_high_po
R$135 \$66 \$67 VSS 2003.841367 res_high_po
* device instance $136 r0 *1 51.61,7.5 res_high_po
R$136 \$65 \$68 VSS 2003.841367 res_high_po
* device instance $137 r0 *1 57.95,7.5 res_high_po
R$137 \$67 \$69 VSS 2003.841367 res_high_po
* device instance $138 r0 *1 64.29,7.5 res_high_po
R$138 \$68 \$70 VSS 2003.841367 res_high_po
* device instance $139 r0 *1 70.63,7.5 res_high_po
R$139 \$69 \$71 VSS 2003.841367 res_high_po
* device instance $140 r0 *1 76.97,7.5 res_high_po
R$140 \$70 \$72 VSS 2003.841367 res_high_po
* device instance $141 r0 *1 83.31,7.5 res_high_po
R$141 \$71 \$73 VSS 2003.841367 res_high_po
* device instance $142 r0 *1 89.65,7.5 res_high_po
R$142 \$72 \$74 VSS 2003.841367 res_high_po
* device instance $143 r0 *1 95.99,7.5 res_high_po
R$143 \$73 \$64 VSS 2003.841367 res_high_po
* device instance $144 r0 *1 102.33,7.5 res_high_po
R$144 \$74 \$63 VSS 2003.841367 res_high_po
* device instance $145 r0 *1 45.27,8.9 res_high_po
R$145 \$65 \$77 VSS 2003.841367 res_high_po
* device instance $146 r0 *1 51.61,8.9 res_high_po
R$146 \$66 \$78 VSS 2003.841367 res_high_po
* device instance $147 r0 *1 57.95,8.9 res_high_po
R$147 \$77 \$79 VSS 2003.841367 res_high_po
* device instance $148 r0 *1 64.29,8.9 res_high_po
R$148 \$78 \$80 VSS 2003.841367 res_high_po
* device instance $149 r0 *1 70.63,8.9 res_high_po
R$149 \$79 \$81 VSS 2003.841367 res_high_po
* device instance $150 r0 *1 76.97,8.9 res_high_po
R$150 \$80 \$82 VSS 2003.841367 res_high_po
* device instance $151 r0 *1 83.31,8.9 res_high_po
R$151 \$81 \$83 VSS 2003.841367 res_high_po
* device instance $152 r0 *1 89.65,8.9 res_high_po
R$152 \$82 \$84 VSS 2003.841367 res_high_po
* device instance $153 r0 *1 95.99,8.9 res_high_po
R$153 \$83 \$85 VSS 2003.841367 res_high_po
* device instance $154 r0 *1 102.33,8.9 res_high_po
R$154 \$84 \$99 VSS 2003.841367 res_high_po
* device instance $155 r0 *1 125.6,8.9 res_high_po
R$155 \$86 \$89 VSS 542.118769 res_high_po
* device instance $156 r0 *1 127.44,8.9 res_high_po
R$156 \$100 \$90 VSS 542.118769 res_high_po
* device instance $157 r0 *1 129.28,8.9 res_high_po
R$157 \$89 \$91 VSS 542.118769 res_high_po
* device instance $158 r0 *1 131.12,8.9 res_high_po
R$158 \$90 \$92 VSS 542.118769 res_high_po
* device instance $159 r0 *1 132.96,8.9 res_high_po
R$159 \$91 \$93 VSS 542.118769 res_high_po
* device instance $160 r0 *1 134.8,8.9 res_high_po
R$160 \$92 \$94 VSS 542.118769 res_high_po
* device instance $161 r0 *1 136.64,8.9 res_high_po
R$161 \$93 \$95 VSS 542.118769 res_high_po
* device instance $162 r0 *1 138.48,8.9 res_high_po
R$162 \$94 \$96 VSS 542.118769 res_high_po
* device instance $163 r0 *1 140.32,8.9 res_high_po
R$163 \$95 \$97 VSS 542.118769 res_high_po
* device instance $164 r0 *1 142.16,8.9 res_high_po
R$164 \$96 \$102 VSS 542.118769 res_high_po
* device instance $165 r0 *1 45.27,10.3 res_high_po
R$165 \$103 \$104 VSS 2003.841367 res_high_po
* device instance $166 r0 *1 45.27,11.7 res_high_po
R$166 \$98 \$121 VSS 2003.841367 res_high_po
* device instance $167 r0 *1 51.61,10.3 res_high_po
R$167 \$98 \$105 VSS 2003.841367 res_high_po
* device instance $168 r0 *1 51.61,11.7 res_high_po
R$168 \$103 \$122 VSS 2003.841367 res_high_po
* device instance $169 r0 *1 57.95,11.7 res_high_po
R$169 \$121 \$123 VSS 2003.841367 res_high_po
* device instance $170 r0 *1 57.95,10.3 res_high_po
R$170 \$104 \$106 VSS 2003.841367 res_high_po
* device instance $171 r0 *1 64.29,11.7 res_high_po
R$171 \$122 \$124 VSS 2003.841367 res_high_po
* device instance $172 r0 *1 64.29,10.3 res_high_po
R$172 \$105 \$107 VSS 2003.841367 res_high_po
* device instance $173 r0 *1 70.63,11.7 res_high_po
R$173 \$123 \$125 VSS 2003.841367 res_high_po
* device instance $174 r0 *1 70.63,10.3 res_high_po
R$174 \$106 \$108 VSS 2003.841367 res_high_po
* device instance $175 r0 *1 76.97,11.7 res_high_po
R$175 \$124 \$126 VSS 2003.841367 res_high_po
* device instance $176 r0 *1 76.97,10.3 res_high_po
R$176 \$107 \$109 VSS 2003.841367 res_high_po
* device instance $177 r0 *1 83.31,11.7 res_high_po
R$177 \$125 \$127 VSS 2003.841367 res_high_po
* device instance $178 r0 *1 83.31,10.3 res_high_po
R$178 \$108 \$110 VSS 2003.841367 res_high_po
* device instance $179 r0 *1 89.65,11.7 res_high_po
R$179 \$126 \$128 VSS 2003.841367 res_high_po
* device instance $180 r0 *1 89.65,10.3 res_high_po
R$180 \$109 \$111 VSS 2003.841367 res_high_po
* device instance $181 r0 *1 95.99,11.7 res_high_po
R$181 \$127 \$129 VSS 2003.841367 res_high_po
* device instance $182 r0 *1 95.99,10.3 res_high_po
R$182 \$110 \$99 VSS 2003.841367 res_high_po
* device instance $183 r0 *1 102.33,10.3 res_high_po
R$183 \$111 \$85 VSS 2003.841367 res_high_po
* device instance $184 r0 *1 102.33,11.7 res_high_po
R$184 \$128 \$130 VSS 2003.841367 res_high_po
* device instance $185 r0 *1 125.6,11.7 res_high_po
R$185 \$101 \$131 VSS 542.118769 res_high_po
* device instance $186 r0 *1 125.6,10.3 res_high_po
R$186 \$112 \$113 VSS 542.118769 res_high_po
* device instance $187 r0 *1 127.44,11.7 res_high_po
R$187 \$112 \$132 VSS 542.118769 res_high_po
* device instance $188 r0 *1 127.44,10.3 res_high_po
R$188 \$101 \$114 VSS 542.118769 res_high_po
* device instance $189 r0 *1 129.28,11.7 res_high_po
R$189 \$131 \$133 VSS 542.118769 res_high_po
* device instance $190 r0 *1 129.28,10.3 res_high_po
R$190 \$113 \$115 VSS 542.118769 res_high_po
* device instance $191 r0 *1 131.12,10.3 res_high_po
R$191 \$114 \$116 VSS 542.118769 res_high_po
* device instance $192 r0 *1 131.12,11.7 res_high_po
R$192 \$132 \$134 VSS 542.118769 res_high_po
* device instance $193 r0 *1 132.96,10.3 res_high_po
R$193 \$115 \$117 VSS 542.118769 res_high_po
* device instance $194 r0 *1 132.96,11.7 res_high_po
R$194 \$133 \$135 VSS 542.118769 res_high_po
* device instance $195 r0 *1 134.8,11.7 res_high_po
R$195 \$134 \$136 VSS 542.118769 res_high_po
* device instance $196 r0 *1 134.8,10.3 res_high_po
R$196 \$116 \$118 VSS 542.118769 res_high_po
* device instance $197 r0 *1 136.64,11.7 res_high_po
R$197 \$135 \$137 VSS 542.118769 res_high_po
* device instance $198 r0 *1 136.64,10.3 res_high_po
R$198 \$117 \$119 VSS 542.118769 res_high_po
* device instance $199 r0 *1 138.48,11.7 res_high_po
R$199 \$136 \$138 VSS 542.118769 res_high_po
* device instance $200 r0 *1 138.48,10.3 res_high_po
R$200 \$118 \$120 VSS 542.118769 res_high_po
* device instance $201 r0 *1 140.32,11.7 res_high_po
R$201 \$137 \$139 VSS 542.118769 res_high_po
* device instance $202 r0 *1 140.32,10.3 res_high_po
R$202 \$119 \$102 VSS 542.118769 res_high_po
* device instance $203 r0 *1 142.16,10.3 res_high_po
R$203 \$120 \$97 VSS 542.118769 res_high_po
* device instance $204 r0 *1 142.16,11.7 res_high_po
R$204 \$138 \$140 VSS 542.118769 res_high_po
* device instance $205 r0 *1 70.63,13.1 res_high_po
R$205 \$100 \$143 VSS 2003.841367 res_high_po
* device instance $206 r0 *1 76.97,13.1 res_high_po
R$206 \$86 \$144 VSS 2003.841367 res_high_po
* device instance $207 r0 *1 83.31,13.1 res_high_po
R$207 \$143 \$145 VSS 2003.841367 res_high_po
* device instance $208 r0 *1 89.65,13.1 res_high_po
R$208 \$144 \$146 VSS 2003.841367 res_high_po
* device instance $209 r0 *1 95.99,13.1 res_high_po
R$209 \$145 \$130 VSS 2003.841367 res_high_po
* device instance $210 r0 *1 102.33,13.1 res_high_po
R$210 \$146 \$129 VSS 2003.841367 res_high_po
* device instance $211 r0 *1 125.6,13.1 res_high_po
R$211 VB \$149 VSS 542.118769 res_high_po
* device instance $212 r0 *1 127.44,13.1 res_high_po
R$212 VA \$150 VSS 542.118769 res_high_po
* device instance $213 r0 *1 129.28,13.1 res_high_po
R$213 \$149 \$151 VSS 542.118769 res_high_po
* device instance $214 r0 *1 131.12,13.1 res_high_po
R$214 \$150 \$152 VSS 542.118769 res_high_po
* device instance $215 r0 *1 132.96,13.1 res_high_po
R$215 \$151 \$153 VSS 542.118769 res_high_po
* device instance $216 r0 *1 134.8,13.1 res_high_po
R$216 \$152 \$154 VSS 542.118769 res_high_po
* device instance $217 r0 *1 136.64,13.1 res_high_po
R$217 \$153 \$155 VSS 542.118769 res_high_po
* device instance $218 r0 *1 138.48,13.1 res_high_po
R$218 \$154 \$156 VSS 542.118769 res_high_po
* device instance $219 r0 *1 140.32,13.1 res_high_po
R$219 \$155 \$140 VSS 542.118769 res_high_po
* device instance $220 r0 *1 142.16,13.1 res_high_po
R$220 \$156 \$139 VSS 542.118769 res_high_po
* device instance $221 r0 *1 174.43,13.1 res_high_po
R$221 VB \$159 VSS 2003.841367 res_high_po
* device instance $222 r0 *1 180.77,13.1 res_high_po
R$222 \$159 \$160 VSS 2003.841367 res_high_po
* device instance $223 r0 *1 187.11,13.1 res_high_po
R$223 \$160 \$161 VSS 2003.841367 res_high_po
* device instance $224 r0 *1 193.45,13.1 res_high_po
R$224 \$161 \$162 VSS 2003.841367 res_high_po
* device instance $225 r0 *1 199.79,13.1 res_high_po
R$225 \$162 \$163 VSS 2003.841367 res_high_po
* device instance $226 r0 *1 206.13,13.1 res_high_po
R$226 \$163 \$164 VSS 2003.841367 res_high_po
* device instance $227 r0 *1 212.47,13.1 res_high_po
R$227 \$164 VBQ VSS 2003.841367 res_high_po
.ENDS bandgap_core_routed
