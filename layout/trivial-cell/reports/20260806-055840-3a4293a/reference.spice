* Hand-written LVS reference netlist for `trivial_mos_array`, the trivial
* known-good cell this flow is proven against (issue #14).
*
* Topology only, matching `klt gen mos_array`'s pinned-default output
* (rows=2, cols=2, dummy=1, flavor=nfet -- 2x2 "real" devices plus one
* dummy column on each side of each row = 8 physically drawn unit NMOS
* transistors, no well/body layer drawn): 4 independent *real* unit NMOS
* devices, each with its own isolated source/drain/gate net (this generator
* draws no GDS pin-label text, so there is nothing to name these nets after),
* bodies tied to the single shared `vsubs` pin. `klt lvs`/`NetlistComparer`
* compares topology, not net names, so the arbitrary `d*/g*/s*` names here do
* not need to match the extracted netlist's own (also arbitrary, `$N`-style)
* net names.
*
* Was 8 M-cards (one per physically-drawn unit, dummy included) through
* issue #62's fourteenth increment; the `klt` pin bumped there
* (2AMLogic/klayout-tools#490 -> #495 / #491 -> #494) makes sky130's curated
* deck declare a `dummy` marker layer and `mos_array` draw it over its own
* `dummy_cells` footprint, so `klt extract --deck sky130` now suppresses the
* 4 dummy-column units the way it already did on other decks (issue #295,
* extended to resistors/bipolars by #462) -- `extract.json`'s
* `dummy_devices_dropped: 4` on this cell, `device_count: 4`. A dummy unit
* has no schematic counterpart by construction (it exists only for
* layout-matching symmetry, per the mos_array generator's own docs), so 4
* M-cards is the topologically correct reference now that the layout side
* can express the distinction -- not a relaxation to chase a smaller
* mismatch count; the previous 8-card version was compensating for a real
* `klt` recognition gap that has since closed.
.SUBCKT trivial_mos_array vsubs
M1 d1 g1 s1 vsubs nfet L=0.28U W=0.42U
M2 d2 g2 s2 vsubs nfet L=0.28U W=0.42U
M3 d3 g3 s3 vsubs nfet L=0.28U W=0.42U
M4 d4 g4 s4 vsubs nfet L=0.28U W=0.42U
.ENDS trivial_mos_array
